.meas tran vdout0_0ck40 FIND v(dout0_0) AT=25.025n

.meas tran vdout0_1ck40 FIND v(dout0_1) AT=25.025n

.meas tran vdout0_2ck40 FIND v(dout0_2) AT=25.025n

.meas tran vdout0_3ck40 FIND v(dout0_3) AT=25.025n

.meas tran vdout0_4ck40 FIND v(dout0_4) AT=25.025n

.meas tran vdout0_5ck40 FIND v(dout0_5) AT=25.025n

.meas tran vdout0_6ck40 FIND v(dout0_6) AT=25.025n

.meas tran vdout0_7ck40 FIND v(dout0_7) AT=25.025n

.meas tran vdout0_8ck40 FIND v(dout0_8) AT=25.025n

.meas tran vdout0_9ck40 FIND v(dout0_9) AT=25.025n

.meas tran vdout0_10ck40 FIND v(dout0_10) AT=25.025n

.meas tran vdout0_11ck40 FIND v(dout0_11) AT=25.025n

.meas tran vdout0_12ck40 FIND v(dout0_12) AT=25.025n

.meas tran vdout0_13ck40 FIND v(dout0_13) AT=25.025n

.meas tran vdout0_14ck40 FIND v(dout0_14) AT=25.025n

.meas tran vdout0_15ck40 FIND v(dout0_15) AT=25.025n

.meas tran vdout0_16ck40 FIND v(dout0_16) AT=25.025n

.meas tran vdout0_17ck40 FIND v(dout0_17) AT=25.025n

.meas tran vdout0_18ck40 FIND v(dout0_18) AT=25.025n

.meas tran vdout0_19ck40 FIND v(dout0_19) AT=25.025n

.meas tran vdout0_20ck40 FIND v(dout0_20) AT=25.025n

.meas tran vdout0_21ck40 FIND v(dout0_21) AT=25.025n

.meas tran vdout0_22ck40 FIND v(dout0_22) AT=25.025n

.meas tran vdout0_23ck40 FIND v(dout0_23) AT=25.025n

.meas tran vdout0_24ck40 FIND v(dout0_24) AT=25.025n

.meas tran vdout0_25ck40 FIND v(dout0_25) AT=25.025n

.meas tran vdout0_26ck40 FIND v(dout0_26) AT=25.025n

.meas tran vdout0_27ck40 FIND v(dout0_27) AT=25.025n

.meas tran vdout0_28ck40 FIND v(dout0_28) AT=25.025n

.meas tran vdout0_29ck40 FIND v(dout0_29) AT=25.025n

.meas tran vdout0_30ck40 FIND v(dout0_30) AT=25.025n

.meas tran vdout0_31ck40 FIND v(dout0_31) AT=25.025n

.meas tran vdout0_0ck50 FIND v(dout0_0) AT=30.025n

.meas tran vdout0_1ck50 FIND v(dout0_1) AT=30.025n

.meas tran vdout0_2ck50 FIND v(dout0_2) AT=30.025n

.meas tran vdout0_3ck50 FIND v(dout0_3) AT=30.025n

.meas tran vdout0_4ck50 FIND v(dout0_4) AT=30.025n

.meas tran vdout0_5ck50 FIND v(dout0_5) AT=30.025n

.meas tran vdout0_6ck50 FIND v(dout0_6) AT=30.025n

.meas tran vdout0_7ck50 FIND v(dout0_7) AT=30.025n

.meas tran vdout0_8ck50 FIND v(dout0_8) AT=30.025n

.meas tran vdout0_9ck50 FIND v(dout0_9) AT=30.025n

.meas tran vdout0_10ck50 FIND v(dout0_10) AT=30.025n

.meas tran vdout0_11ck50 FIND v(dout0_11) AT=30.025n

.meas tran vdout0_12ck50 FIND v(dout0_12) AT=30.025n

.meas tran vdout0_13ck50 FIND v(dout0_13) AT=30.025n

.meas tran vdout0_14ck50 FIND v(dout0_14) AT=30.025n

.meas tran vdout0_15ck50 FIND v(dout0_15) AT=30.025n

.meas tran vdout0_16ck50 FIND v(dout0_16) AT=30.025n

.meas tran vdout0_17ck50 FIND v(dout0_17) AT=30.025n

.meas tran vdout0_18ck50 FIND v(dout0_18) AT=30.025n

.meas tran vdout0_19ck50 FIND v(dout0_19) AT=30.025n

.meas tran vdout0_20ck50 FIND v(dout0_20) AT=30.025n

.meas tran vdout0_21ck50 FIND v(dout0_21) AT=30.025n

.meas tran vdout0_22ck50 FIND v(dout0_22) AT=30.025n

.meas tran vdout0_23ck50 FIND v(dout0_23) AT=30.025n

.meas tran vdout0_24ck50 FIND v(dout0_24) AT=30.025n

.meas tran vdout0_25ck50 FIND v(dout0_25) AT=30.025n

.meas tran vdout0_26ck50 FIND v(dout0_26) AT=30.025n

.meas tran vdout0_27ck50 FIND v(dout0_27) AT=30.025n

.meas tran vdout0_28ck50 FIND v(dout0_28) AT=30.025n

.meas tran vdout0_29ck50 FIND v(dout0_29) AT=30.025n

.meas tran vdout0_30ck50 FIND v(dout0_30) AT=30.025n

.meas tran vdout0_31ck50 FIND v(dout0_31) AT=30.025n

.meas tran vdout0_0ck90 FIND v(dout0_0) AT=50.025n

.meas tran vdout0_1ck90 FIND v(dout0_1) AT=50.025n

.meas tran vdout0_2ck90 FIND v(dout0_2) AT=50.025n

.meas tran vdout0_3ck90 FIND v(dout0_3) AT=50.025n

.meas tran vdout0_4ck90 FIND v(dout0_4) AT=50.025n

.meas tran vdout0_5ck90 FIND v(dout0_5) AT=50.025n

.meas tran vdout0_6ck90 FIND v(dout0_6) AT=50.025n

.meas tran vdout0_7ck90 FIND v(dout0_7) AT=50.025n

.meas tran vdout0_8ck90 FIND v(dout0_8) AT=50.025n

.meas tran vdout0_9ck90 FIND v(dout0_9) AT=50.025n

.meas tran vdout0_10ck90 FIND v(dout0_10) AT=50.025n

.meas tran vdout0_11ck90 FIND v(dout0_11) AT=50.025n

.meas tran vdout0_12ck90 FIND v(dout0_12) AT=50.025n

.meas tran vdout0_13ck90 FIND v(dout0_13) AT=50.025n

.meas tran vdout0_14ck90 FIND v(dout0_14) AT=50.025n

.meas tran vdout0_15ck90 FIND v(dout0_15) AT=50.025n

.meas tran vdout0_16ck90 FIND v(dout0_16) AT=50.025n

.meas tran vdout0_17ck90 FIND v(dout0_17) AT=50.025n

.meas tran vdout0_18ck90 FIND v(dout0_18) AT=50.025n

.meas tran vdout0_19ck90 FIND v(dout0_19) AT=50.025n

.meas tran vdout0_20ck90 FIND v(dout0_20) AT=50.025n

.meas tran vdout0_21ck90 FIND v(dout0_21) AT=50.025n

.meas tran vdout0_22ck90 FIND v(dout0_22) AT=50.025n

.meas tran vdout0_23ck90 FIND v(dout0_23) AT=50.025n

.meas tran vdout0_24ck90 FIND v(dout0_24) AT=50.025n

.meas tran vdout0_25ck90 FIND v(dout0_25) AT=50.025n

.meas tran vdout0_26ck90 FIND v(dout0_26) AT=50.025n

.meas tran vdout0_27ck90 FIND v(dout0_27) AT=50.025n

.meas tran vdout0_28ck90 FIND v(dout0_28) AT=50.025n

.meas tran vdout0_29ck90 FIND v(dout0_29) AT=50.025n

.meas tran vdout0_30ck90 FIND v(dout0_30) AT=50.025n

.meas tran vdout0_31ck90 FIND v(dout0_31) AT=50.025n

.meas tran vdout0_0ck100 FIND v(dout0_0) AT=55.025n

.meas tran vdout0_1ck100 FIND v(dout0_1) AT=55.025n

.meas tran vdout0_2ck100 FIND v(dout0_2) AT=55.025n

.meas tran vdout0_3ck100 FIND v(dout0_3) AT=55.025n

.meas tran vdout0_4ck100 FIND v(dout0_4) AT=55.025n

.meas tran vdout0_5ck100 FIND v(dout0_5) AT=55.025n

.meas tran vdout0_6ck100 FIND v(dout0_6) AT=55.025n

.meas tran vdout0_7ck100 FIND v(dout0_7) AT=55.025n

.meas tran vdout0_8ck100 FIND v(dout0_8) AT=55.025n

.meas tran vdout0_9ck100 FIND v(dout0_9) AT=55.025n

.meas tran vdout0_10ck100 FIND v(dout0_10) AT=55.025n

.meas tran vdout0_11ck100 FIND v(dout0_11) AT=55.025n

.meas tran vdout0_12ck100 FIND v(dout0_12) AT=55.025n

.meas tran vdout0_13ck100 FIND v(dout0_13) AT=55.025n

.meas tran vdout0_14ck100 FIND v(dout0_14) AT=55.025n

.meas tran vdout0_15ck100 FIND v(dout0_15) AT=55.025n

.meas tran vdout0_16ck100 FIND v(dout0_16) AT=55.025n

.meas tran vdout0_17ck100 FIND v(dout0_17) AT=55.025n

.meas tran vdout0_18ck100 FIND v(dout0_18) AT=55.025n

.meas tran vdout0_19ck100 FIND v(dout0_19) AT=55.025n

.meas tran vdout0_20ck100 FIND v(dout0_20) AT=55.025n

.meas tran vdout0_21ck100 FIND v(dout0_21) AT=55.025n

.meas tran vdout0_22ck100 FIND v(dout0_22) AT=55.025n

.meas tran vdout0_23ck100 FIND v(dout0_23) AT=55.025n

.meas tran vdout0_24ck100 FIND v(dout0_24) AT=55.025n

.meas tran vdout0_25ck100 FIND v(dout0_25) AT=55.025n

.meas tran vdout0_26ck100 FIND v(dout0_26) AT=55.025n

.meas tran vdout0_27ck100 FIND v(dout0_27) AT=55.025n

.meas tran vdout0_28ck100 FIND v(dout0_28) AT=55.025n

.meas tran vdout0_29ck100 FIND v(dout0_29) AT=55.025n

.meas tran vdout0_30ck100 FIND v(dout0_30) AT=55.025n

.meas tran vdout0_31ck100 FIND v(dout0_31) AT=55.025n

.meas tran vdout0_0ck110 FIND v(dout0_0) AT=60.025n

.meas tran vdout0_1ck110 FIND v(dout0_1) AT=60.025n

.meas tran vdout0_2ck110 FIND v(dout0_2) AT=60.025n

.meas tran vdout0_3ck110 FIND v(dout0_3) AT=60.025n

.meas tran vdout0_4ck110 FIND v(dout0_4) AT=60.025n

.meas tran vdout0_5ck110 FIND v(dout0_5) AT=60.025n

.meas tran vdout0_6ck110 FIND v(dout0_6) AT=60.025n

.meas tran vdout0_7ck110 FIND v(dout0_7) AT=60.025n

.meas tran vdout0_8ck110 FIND v(dout0_8) AT=60.025n

.meas tran vdout0_9ck110 FIND v(dout0_9) AT=60.025n

.meas tran vdout0_10ck110 FIND v(dout0_10) AT=60.025n

.meas tran vdout0_11ck110 FIND v(dout0_11) AT=60.025n

.meas tran vdout0_12ck110 FIND v(dout0_12) AT=60.025n

.meas tran vdout0_13ck110 FIND v(dout0_13) AT=60.025n

.meas tran vdout0_14ck110 FIND v(dout0_14) AT=60.025n

.meas tran vdout0_15ck110 FIND v(dout0_15) AT=60.025n

.meas tran vdout0_16ck110 FIND v(dout0_16) AT=60.025n

.meas tran vdout0_17ck110 FIND v(dout0_17) AT=60.025n

.meas tran vdout0_18ck110 FIND v(dout0_18) AT=60.025n

.meas tran vdout0_19ck110 FIND v(dout0_19) AT=60.025n

.meas tran vdout0_20ck110 FIND v(dout0_20) AT=60.025n

.meas tran vdout0_21ck110 FIND v(dout0_21) AT=60.025n

.meas tran vdout0_22ck110 FIND v(dout0_22) AT=60.025n

.meas tran vdout0_23ck110 FIND v(dout0_23) AT=60.025n

.meas tran vdout0_24ck110 FIND v(dout0_24) AT=60.025n

.meas tran vdout0_25ck110 FIND v(dout0_25) AT=60.025n

.meas tran vdout0_26ck110 FIND v(dout0_26) AT=60.025n

.meas tran vdout0_27ck110 FIND v(dout0_27) AT=60.025n

.meas tran vdout0_28ck110 FIND v(dout0_28) AT=60.025n

.meas tran vdout0_29ck110 FIND v(dout0_29) AT=60.025n

.meas tran vdout0_30ck110 FIND v(dout0_30) AT=60.025n

.meas tran vdout0_31ck110 FIND v(dout0_31) AT=60.025n

.meas tran vdout0_0ck130 FIND v(dout0_0) AT=70.025n

.meas tran vdout0_1ck130 FIND v(dout0_1) AT=70.025n

.meas tran vdout0_2ck130 FIND v(dout0_2) AT=70.025n

.meas tran vdout0_3ck130 FIND v(dout0_3) AT=70.025n

.meas tran vdout0_4ck130 FIND v(dout0_4) AT=70.025n

.meas tran vdout0_5ck130 FIND v(dout0_5) AT=70.025n

.meas tran vdout0_6ck130 FIND v(dout0_6) AT=70.025n

.meas tran vdout0_7ck130 FIND v(dout0_7) AT=70.025n

.meas tran vdout0_8ck130 FIND v(dout0_8) AT=70.025n

.meas tran vdout0_9ck130 FIND v(dout0_9) AT=70.025n

.meas tran vdout0_10ck130 FIND v(dout0_10) AT=70.025n

.meas tran vdout0_11ck130 FIND v(dout0_11) AT=70.025n

.meas tran vdout0_12ck130 FIND v(dout0_12) AT=70.025n

.meas tran vdout0_13ck130 FIND v(dout0_13) AT=70.025n

.meas tran vdout0_14ck130 FIND v(dout0_14) AT=70.025n

.meas tran vdout0_15ck130 FIND v(dout0_15) AT=70.025n

.meas tran vdout0_16ck130 FIND v(dout0_16) AT=70.025n

.meas tran vdout0_17ck130 FIND v(dout0_17) AT=70.025n

.meas tran vdout0_18ck130 FIND v(dout0_18) AT=70.025n

.meas tran vdout0_19ck130 FIND v(dout0_19) AT=70.025n

.meas tran vdout0_20ck130 FIND v(dout0_20) AT=70.025n

.meas tran vdout0_21ck130 FIND v(dout0_21) AT=70.025n

.meas tran vdout0_22ck130 FIND v(dout0_22) AT=70.025n

.meas tran vdout0_23ck130 FIND v(dout0_23) AT=70.025n

.meas tran vdout0_24ck130 FIND v(dout0_24) AT=70.025n

.meas tran vdout0_25ck130 FIND v(dout0_25) AT=70.025n

.meas tran vdout0_26ck130 FIND v(dout0_26) AT=70.025n

.meas tran vdout0_27ck130 FIND v(dout0_27) AT=70.025n

.meas tran vdout0_28ck130 FIND v(dout0_28) AT=70.025n

.meas tran vdout0_29ck130 FIND v(dout0_29) AT=70.025n

.meas tran vdout0_30ck130 FIND v(dout0_30) AT=70.025n

.meas tran vdout0_31ck130 FIND v(dout0_31) AT=70.025n

.meas tran vdout0_0ck170 FIND v(dout0_0) AT=90.025n

.meas tran vdout0_1ck170 FIND v(dout0_1) AT=90.025n

.meas tran vdout0_2ck170 FIND v(dout0_2) AT=90.025n

.meas tran vdout0_3ck170 FIND v(dout0_3) AT=90.025n

.meas tran vdout0_4ck170 FIND v(dout0_4) AT=90.025n

.meas tran vdout0_5ck170 FIND v(dout0_5) AT=90.025n

.meas tran vdout0_6ck170 FIND v(dout0_6) AT=90.025n

.meas tran vdout0_7ck170 FIND v(dout0_7) AT=90.025n

.meas tran vdout0_8ck170 FIND v(dout0_8) AT=90.025n

.meas tran vdout0_9ck170 FIND v(dout0_9) AT=90.025n

.meas tran vdout0_10ck170 FIND v(dout0_10) AT=90.025n

.meas tran vdout0_11ck170 FIND v(dout0_11) AT=90.025n

.meas tran vdout0_12ck170 FIND v(dout0_12) AT=90.025n

.meas tran vdout0_13ck170 FIND v(dout0_13) AT=90.025n

.meas tran vdout0_14ck170 FIND v(dout0_14) AT=90.025n

.meas tran vdout0_15ck170 FIND v(dout0_15) AT=90.025n

.meas tran vdout0_16ck170 FIND v(dout0_16) AT=90.025n

.meas tran vdout0_17ck170 FIND v(dout0_17) AT=90.025n

.meas tran vdout0_18ck170 FIND v(dout0_18) AT=90.025n

.meas tran vdout0_19ck170 FIND v(dout0_19) AT=90.025n

.meas tran vdout0_20ck170 FIND v(dout0_20) AT=90.025n

.meas tran vdout0_21ck170 FIND v(dout0_21) AT=90.025n

.meas tran vdout0_22ck170 FIND v(dout0_22) AT=90.025n

.meas tran vdout0_23ck170 FIND v(dout0_23) AT=90.025n

.meas tran vdout0_24ck170 FIND v(dout0_24) AT=90.025n

.meas tran vdout0_25ck170 FIND v(dout0_25) AT=90.025n

.meas tran vdout0_26ck170 FIND v(dout0_26) AT=90.025n

.meas tran vdout0_27ck170 FIND v(dout0_27) AT=90.025n

.meas tran vdout0_28ck170 FIND v(dout0_28) AT=90.025n

.meas tran vdout0_29ck170 FIND v(dout0_29) AT=90.025n

.meas tran vdout0_30ck170 FIND v(dout0_30) AT=90.025n

.meas tran vdout0_31ck170 FIND v(dout0_31) AT=90.025n

.meas tran vdout0_0ck180 FIND v(dout0_0) AT=95.025n

.meas tran vdout0_1ck180 FIND v(dout0_1) AT=95.025n

.meas tran vdout0_2ck180 FIND v(dout0_2) AT=95.025n

.meas tran vdout0_3ck180 FIND v(dout0_3) AT=95.025n

.meas tran vdout0_4ck180 FIND v(dout0_4) AT=95.025n

.meas tran vdout0_5ck180 FIND v(dout0_5) AT=95.025n

.meas tran vdout0_6ck180 FIND v(dout0_6) AT=95.025n

.meas tran vdout0_7ck180 FIND v(dout0_7) AT=95.025n

.meas tran vdout0_8ck180 FIND v(dout0_8) AT=95.025n

.meas tran vdout0_9ck180 FIND v(dout0_9) AT=95.025n

.meas tran vdout0_10ck180 FIND v(dout0_10) AT=95.025n

.meas tran vdout0_11ck180 FIND v(dout0_11) AT=95.025n

.meas tran vdout0_12ck180 FIND v(dout0_12) AT=95.025n

.meas tran vdout0_13ck180 FIND v(dout0_13) AT=95.025n

.meas tran vdout0_14ck180 FIND v(dout0_14) AT=95.025n

.meas tran vdout0_15ck180 FIND v(dout0_15) AT=95.025n

.meas tran vdout0_16ck180 FIND v(dout0_16) AT=95.025n

.meas tran vdout0_17ck180 FIND v(dout0_17) AT=95.025n

.meas tran vdout0_18ck180 FIND v(dout0_18) AT=95.025n

.meas tran vdout0_19ck180 FIND v(dout0_19) AT=95.025n

.meas tran vdout0_20ck180 FIND v(dout0_20) AT=95.025n

.meas tran vdout0_21ck180 FIND v(dout0_21) AT=95.025n

.meas tran vdout0_22ck180 FIND v(dout0_22) AT=95.025n

.meas tran vdout0_23ck180 FIND v(dout0_23) AT=95.025n

.meas tran vdout0_24ck180 FIND v(dout0_24) AT=95.025n

.meas tran vdout0_25ck180 FIND v(dout0_25) AT=95.025n

.meas tran vdout0_26ck180 FIND v(dout0_26) AT=95.025n

.meas tran vdout0_27ck180 FIND v(dout0_27) AT=95.025n

.meas tran vdout0_28ck180 FIND v(dout0_28) AT=95.025n

.meas tran vdout0_29ck180 FIND v(dout0_29) AT=95.025n

.meas tran vdout0_30ck180 FIND v(dout0_30) AT=95.025n

.meas tran vdout0_31ck180 FIND v(dout0_31) AT=95.025n

.meas tran vdout0_0ck220 FIND v(dout0_0) AT=115.025n

.meas tran vdout0_1ck220 FIND v(dout0_1) AT=115.025n

.meas tran vdout0_2ck220 FIND v(dout0_2) AT=115.025n

.meas tran vdout0_3ck220 FIND v(dout0_3) AT=115.025n

.meas tran vdout0_4ck220 FIND v(dout0_4) AT=115.025n

.meas tran vdout0_5ck220 FIND v(dout0_5) AT=115.025n

.meas tran vdout0_6ck220 FIND v(dout0_6) AT=115.025n

.meas tran vdout0_7ck220 FIND v(dout0_7) AT=115.025n

.meas tran vdout0_8ck220 FIND v(dout0_8) AT=115.025n

.meas tran vdout0_9ck220 FIND v(dout0_9) AT=115.025n

.meas tran vdout0_10ck220 FIND v(dout0_10) AT=115.025n

.meas tran vdout0_11ck220 FIND v(dout0_11) AT=115.025n

.meas tran vdout0_12ck220 FIND v(dout0_12) AT=115.025n

.meas tran vdout0_13ck220 FIND v(dout0_13) AT=115.025n

.meas tran vdout0_14ck220 FIND v(dout0_14) AT=115.025n

.meas tran vdout0_15ck220 FIND v(dout0_15) AT=115.025n

.meas tran vdout0_16ck220 FIND v(dout0_16) AT=115.025n

.meas tran vdout0_17ck220 FIND v(dout0_17) AT=115.025n

.meas tran vdout0_18ck220 FIND v(dout0_18) AT=115.025n

.meas tran vdout0_19ck220 FIND v(dout0_19) AT=115.025n

.meas tran vdout0_20ck220 FIND v(dout0_20) AT=115.025n

.meas tran vdout0_21ck220 FIND v(dout0_21) AT=115.025n

.meas tran vdout0_22ck220 FIND v(dout0_22) AT=115.025n

.meas tran vdout0_23ck220 FIND v(dout0_23) AT=115.025n

.meas tran vdout0_24ck220 FIND v(dout0_24) AT=115.025n

.meas tran vdout0_25ck220 FIND v(dout0_25) AT=115.025n

.meas tran vdout0_26ck220 FIND v(dout0_26) AT=115.025n

.meas tran vdout0_27ck220 FIND v(dout0_27) AT=115.025n

.meas tran vdout0_28ck220 FIND v(dout0_28) AT=115.025n

.meas tran vdout0_29ck220 FIND v(dout0_29) AT=115.025n

.meas tran vdout0_30ck220 FIND v(dout0_30) AT=115.025n

.meas tran vdout0_31ck220 FIND v(dout0_31) AT=115.025n

.meas tran vdout0_0ck260 FIND v(dout0_0) AT=135.025n

.meas tran vdout0_1ck260 FIND v(dout0_1) AT=135.025n

.meas tran vdout0_2ck260 FIND v(dout0_2) AT=135.025n

.meas tran vdout0_3ck260 FIND v(dout0_3) AT=135.025n

.meas tran vdout0_4ck260 FIND v(dout0_4) AT=135.025n

.meas tran vdout0_5ck260 FIND v(dout0_5) AT=135.025n

.meas tran vdout0_6ck260 FIND v(dout0_6) AT=135.025n

.meas tran vdout0_7ck260 FIND v(dout0_7) AT=135.025n

.meas tran vdout0_8ck260 FIND v(dout0_8) AT=135.025n

.meas tran vdout0_9ck260 FIND v(dout0_9) AT=135.025n

.meas tran vdout0_10ck260 FIND v(dout0_10) AT=135.025n

.meas tran vdout0_11ck260 FIND v(dout0_11) AT=135.025n

.meas tran vdout0_12ck260 FIND v(dout0_12) AT=135.025n

.meas tran vdout0_13ck260 FIND v(dout0_13) AT=135.025n

.meas tran vdout0_14ck260 FIND v(dout0_14) AT=135.025n

.meas tran vdout0_15ck260 FIND v(dout0_15) AT=135.025n

.meas tran vdout0_16ck260 FIND v(dout0_16) AT=135.025n

.meas tran vdout0_17ck260 FIND v(dout0_17) AT=135.025n

.meas tran vdout0_18ck260 FIND v(dout0_18) AT=135.025n

.meas tran vdout0_19ck260 FIND v(dout0_19) AT=135.025n

.meas tran vdout0_20ck260 FIND v(dout0_20) AT=135.025n

.meas tran vdout0_21ck260 FIND v(dout0_21) AT=135.025n

.meas tran vdout0_22ck260 FIND v(dout0_22) AT=135.025n

.meas tran vdout0_23ck260 FIND v(dout0_23) AT=135.025n

.meas tran vdout0_24ck260 FIND v(dout0_24) AT=135.025n

.meas tran vdout0_25ck260 FIND v(dout0_25) AT=135.025n

.meas tran vdout0_26ck260 FIND v(dout0_26) AT=135.025n

.meas tran vdout0_27ck260 FIND v(dout0_27) AT=135.025n

.meas tran vdout0_28ck260 FIND v(dout0_28) AT=135.025n

.meas tran vdout0_29ck260 FIND v(dout0_29) AT=135.025n

.meas tran vdout0_30ck260 FIND v(dout0_30) AT=135.025n

.meas tran vdout0_31ck260 FIND v(dout0_31) AT=135.025n

.meas tran vdout0_0ck320 FIND v(dout0_0) AT=165.025n

.meas tran vdout0_1ck320 FIND v(dout0_1) AT=165.025n

.meas tran vdout0_2ck320 FIND v(dout0_2) AT=165.025n

.meas tran vdout0_3ck320 FIND v(dout0_3) AT=165.025n

.meas tran vdout0_4ck320 FIND v(dout0_4) AT=165.025n

.meas tran vdout0_5ck320 FIND v(dout0_5) AT=165.025n

.meas tran vdout0_6ck320 FIND v(dout0_6) AT=165.025n

.meas tran vdout0_7ck320 FIND v(dout0_7) AT=165.025n

.meas tran vdout0_8ck320 FIND v(dout0_8) AT=165.025n

.meas tran vdout0_9ck320 FIND v(dout0_9) AT=165.025n

.meas tran vdout0_10ck320 FIND v(dout0_10) AT=165.025n

.meas tran vdout0_11ck320 FIND v(dout0_11) AT=165.025n

.meas tran vdout0_12ck320 FIND v(dout0_12) AT=165.025n

.meas tran vdout0_13ck320 FIND v(dout0_13) AT=165.025n

.meas tran vdout0_14ck320 FIND v(dout0_14) AT=165.025n

.meas tran vdout0_15ck320 FIND v(dout0_15) AT=165.025n

.meas tran vdout0_16ck320 FIND v(dout0_16) AT=165.025n

.meas tran vdout0_17ck320 FIND v(dout0_17) AT=165.025n

.meas tran vdout0_18ck320 FIND v(dout0_18) AT=165.025n

.meas tran vdout0_19ck320 FIND v(dout0_19) AT=165.025n

.meas tran vdout0_20ck320 FIND v(dout0_20) AT=165.025n

.meas tran vdout0_21ck320 FIND v(dout0_21) AT=165.025n

.meas tran vdout0_22ck320 FIND v(dout0_22) AT=165.025n

.meas tran vdout0_23ck320 FIND v(dout0_23) AT=165.025n

.meas tran vdout0_24ck320 FIND v(dout0_24) AT=165.025n

.meas tran vdout0_25ck320 FIND v(dout0_25) AT=165.025n

.meas tran vdout0_26ck320 FIND v(dout0_26) AT=165.025n

.meas tran vdout0_27ck320 FIND v(dout0_27) AT=165.025n

.meas tran vdout0_28ck320 FIND v(dout0_28) AT=165.025n

.meas tran vdout0_29ck320 FIND v(dout0_29) AT=165.025n

.meas tran vdout0_30ck320 FIND v(dout0_30) AT=165.025n

.meas tran vdout0_31ck320 FIND v(dout0_31) AT=165.025n

.meas tran vdout0_0ck340 FIND v(dout0_0) AT=175.025n

.meas tran vdout0_1ck340 FIND v(dout0_1) AT=175.025n

.meas tran vdout0_2ck340 FIND v(dout0_2) AT=175.025n

.meas tran vdout0_3ck340 FIND v(dout0_3) AT=175.025n

.meas tran vdout0_4ck340 FIND v(dout0_4) AT=175.025n

.meas tran vdout0_5ck340 FIND v(dout0_5) AT=175.025n

.meas tran vdout0_6ck340 FIND v(dout0_6) AT=175.025n

.meas tran vdout0_7ck340 FIND v(dout0_7) AT=175.025n

.meas tran vdout0_8ck340 FIND v(dout0_8) AT=175.025n

.meas tran vdout0_9ck340 FIND v(dout0_9) AT=175.025n

.meas tran vdout0_10ck340 FIND v(dout0_10) AT=175.025n

.meas tran vdout0_11ck340 FIND v(dout0_11) AT=175.025n

.meas tran vdout0_12ck340 FIND v(dout0_12) AT=175.025n

.meas tran vdout0_13ck340 FIND v(dout0_13) AT=175.025n

.meas tran vdout0_14ck340 FIND v(dout0_14) AT=175.025n

.meas tran vdout0_15ck340 FIND v(dout0_15) AT=175.025n

.meas tran vdout0_16ck340 FIND v(dout0_16) AT=175.025n

.meas tran vdout0_17ck340 FIND v(dout0_17) AT=175.025n

.meas tran vdout0_18ck340 FIND v(dout0_18) AT=175.025n

.meas tran vdout0_19ck340 FIND v(dout0_19) AT=175.025n

.meas tran vdout0_20ck340 FIND v(dout0_20) AT=175.025n

.meas tran vdout0_21ck340 FIND v(dout0_21) AT=175.025n

.meas tran vdout0_22ck340 FIND v(dout0_22) AT=175.025n

.meas tran vdout0_23ck340 FIND v(dout0_23) AT=175.025n

.meas tran vdout0_24ck340 FIND v(dout0_24) AT=175.025n

.meas tran vdout0_25ck340 FIND v(dout0_25) AT=175.025n

.meas tran vdout0_26ck340 FIND v(dout0_26) AT=175.025n

.meas tran vdout0_27ck340 FIND v(dout0_27) AT=175.025n

.meas tran vdout0_28ck340 FIND v(dout0_28) AT=175.025n

.meas tran vdout0_29ck340 FIND v(dout0_29) AT=175.025n

.meas tran vdout0_30ck340 FIND v(dout0_30) AT=175.025n

.meas tran vdout0_31ck340 FIND v(dout0_31) AT=175.025n

.meas tran vdout0_0ck350 FIND v(dout0_0) AT=180.025n

.meas tran vdout0_1ck350 FIND v(dout0_1) AT=180.025n

.meas tran vdout0_2ck350 FIND v(dout0_2) AT=180.025n

.meas tran vdout0_3ck350 FIND v(dout0_3) AT=180.025n

.meas tran vdout0_4ck350 FIND v(dout0_4) AT=180.025n

.meas tran vdout0_5ck350 FIND v(dout0_5) AT=180.025n

.meas tran vdout0_6ck350 FIND v(dout0_6) AT=180.025n

.meas tran vdout0_7ck350 FIND v(dout0_7) AT=180.025n

.meas tran vdout0_8ck350 FIND v(dout0_8) AT=180.025n

.meas tran vdout0_9ck350 FIND v(dout0_9) AT=180.025n

.meas tran vdout0_10ck350 FIND v(dout0_10) AT=180.025n

.meas tran vdout0_11ck350 FIND v(dout0_11) AT=180.025n

.meas tran vdout0_12ck350 FIND v(dout0_12) AT=180.025n

.meas tran vdout0_13ck350 FIND v(dout0_13) AT=180.025n

.meas tran vdout0_14ck350 FIND v(dout0_14) AT=180.025n

.meas tran vdout0_15ck350 FIND v(dout0_15) AT=180.025n

.meas tran vdout0_16ck350 FIND v(dout0_16) AT=180.025n

.meas tran vdout0_17ck350 FIND v(dout0_17) AT=180.025n

.meas tran vdout0_18ck350 FIND v(dout0_18) AT=180.025n

.meas tran vdout0_19ck350 FIND v(dout0_19) AT=180.025n

.meas tran vdout0_20ck350 FIND v(dout0_20) AT=180.025n

.meas tran vdout0_21ck350 FIND v(dout0_21) AT=180.025n

.meas tran vdout0_22ck350 FIND v(dout0_22) AT=180.025n

.meas tran vdout0_23ck350 FIND v(dout0_23) AT=180.025n

.meas tran vdout0_24ck350 FIND v(dout0_24) AT=180.025n

.meas tran vdout0_25ck350 FIND v(dout0_25) AT=180.025n

.meas tran vdout0_26ck350 FIND v(dout0_26) AT=180.025n

.meas tran vdout0_27ck350 FIND v(dout0_27) AT=180.025n

.meas tran vdout0_28ck350 FIND v(dout0_28) AT=180.025n

.meas tran vdout0_29ck350 FIND v(dout0_29) AT=180.025n

.meas tran vdout0_30ck350 FIND v(dout0_30) AT=180.025n

.meas tran vdout0_31ck350 FIND v(dout0_31) AT=180.025n

.meas tran vdout0_0ck370 FIND v(dout0_0) AT=190.025n

.meas tran vdout0_1ck370 FIND v(dout0_1) AT=190.025n

.meas tran vdout0_2ck370 FIND v(dout0_2) AT=190.025n

.meas tran vdout0_3ck370 FIND v(dout0_3) AT=190.025n

.meas tran vdout0_4ck370 FIND v(dout0_4) AT=190.025n

.meas tran vdout0_5ck370 FIND v(dout0_5) AT=190.025n

.meas tran vdout0_6ck370 FIND v(dout0_6) AT=190.025n

.meas tran vdout0_7ck370 FIND v(dout0_7) AT=190.025n

.meas tran vdout0_8ck370 FIND v(dout0_8) AT=190.025n

.meas tran vdout0_9ck370 FIND v(dout0_9) AT=190.025n

.meas tran vdout0_10ck370 FIND v(dout0_10) AT=190.025n

.meas tran vdout0_11ck370 FIND v(dout0_11) AT=190.025n

.meas tran vdout0_12ck370 FIND v(dout0_12) AT=190.025n

.meas tran vdout0_13ck370 FIND v(dout0_13) AT=190.025n

.meas tran vdout0_14ck370 FIND v(dout0_14) AT=190.025n

.meas tran vdout0_15ck370 FIND v(dout0_15) AT=190.025n

.meas tran vdout0_16ck370 FIND v(dout0_16) AT=190.025n

.meas tran vdout0_17ck370 FIND v(dout0_17) AT=190.025n

.meas tran vdout0_18ck370 FIND v(dout0_18) AT=190.025n

.meas tran vdout0_19ck370 FIND v(dout0_19) AT=190.025n

.meas tran vdout0_20ck370 FIND v(dout0_20) AT=190.025n

.meas tran vdout0_21ck370 FIND v(dout0_21) AT=190.025n

.meas tran vdout0_22ck370 FIND v(dout0_22) AT=190.025n

.meas tran vdout0_23ck370 FIND v(dout0_23) AT=190.025n

.meas tran vdout0_24ck370 FIND v(dout0_24) AT=190.025n

.meas tran vdout0_25ck370 FIND v(dout0_25) AT=190.025n

.meas tran vdout0_26ck370 FIND v(dout0_26) AT=190.025n

.meas tran vdout0_27ck370 FIND v(dout0_27) AT=190.025n

.meas tran vdout0_28ck370 FIND v(dout0_28) AT=190.025n

.meas tran vdout0_29ck370 FIND v(dout0_29) AT=190.025n

.meas tran vdout0_30ck370 FIND v(dout0_30) AT=190.025n

.meas tran vdout0_31ck370 FIND v(dout0_31) AT=190.025n

.meas tran vdout0_0ck390 FIND v(dout0_0) AT=200.025n

.meas tran vdout0_1ck390 FIND v(dout0_1) AT=200.025n

.meas tran vdout0_2ck390 FIND v(dout0_2) AT=200.025n

.meas tran vdout0_3ck390 FIND v(dout0_3) AT=200.025n

.meas tran vdout0_4ck390 FIND v(dout0_4) AT=200.025n

.meas tran vdout0_5ck390 FIND v(dout0_5) AT=200.025n

.meas tran vdout0_6ck390 FIND v(dout0_6) AT=200.025n

.meas tran vdout0_7ck390 FIND v(dout0_7) AT=200.025n

.meas tran vdout0_8ck390 FIND v(dout0_8) AT=200.025n

.meas tran vdout0_9ck390 FIND v(dout0_9) AT=200.025n

.meas tran vdout0_10ck390 FIND v(dout0_10) AT=200.025n

.meas tran vdout0_11ck390 FIND v(dout0_11) AT=200.025n

.meas tran vdout0_12ck390 FIND v(dout0_12) AT=200.025n

.meas tran vdout0_13ck390 FIND v(dout0_13) AT=200.025n

.meas tran vdout0_14ck390 FIND v(dout0_14) AT=200.025n

.meas tran vdout0_15ck390 FIND v(dout0_15) AT=200.025n

.meas tran vdout0_16ck390 FIND v(dout0_16) AT=200.025n

.meas tran vdout0_17ck390 FIND v(dout0_17) AT=200.025n

.meas tran vdout0_18ck390 FIND v(dout0_18) AT=200.025n

.meas tran vdout0_19ck390 FIND v(dout0_19) AT=200.025n

.meas tran vdout0_20ck390 FIND v(dout0_20) AT=200.025n

.meas tran vdout0_21ck390 FIND v(dout0_21) AT=200.025n

.meas tran vdout0_22ck390 FIND v(dout0_22) AT=200.025n

.meas tran vdout0_23ck390 FIND v(dout0_23) AT=200.025n

.meas tran vdout0_24ck390 FIND v(dout0_24) AT=200.025n

.meas tran vdout0_25ck390 FIND v(dout0_25) AT=200.025n

.meas tran vdout0_26ck390 FIND v(dout0_26) AT=200.025n

.meas tran vdout0_27ck390 FIND v(dout0_27) AT=200.025n

.meas tran vdout0_28ck390 FIND v(dout0_28) AT=200.025n

.meas tran vdout0_29ck390 FIND v(dout0_29) AT=200.025n

.meas tran vdout0_30ck390 FIND v(dout0_30) AT=200.025n

.meas tran vdout0_31ck390 FIND v(dout0_31) AT=200.025n

.meas tran vdout0_0ck430 FIND v(dout0_0) AT=220.025n

.meas tran vdout0_1ck430 FIND v(dout0_1) AT=220.025n

.meas tran vdout0_2ck430 FIND v(dout0_2) AT=220.025n

.meas tran vdout0_3ck430 FIND v(dout0_3) AT=220.025n

.meas tran vdout0_4ck430 FIND v(dout0_4) AT=220.025n

.meas tran vdout0_5ck430 FIND v(dout0_5) AT=220.025n

.meas tran vdout0_6ck430 FIND v(dout0_6) AT=220.025n

.meas tran vdout0_7ck430 FIND v(dout0_7) AT=220.025n

.meas tran vdout0_8ck430 FIND v(dout0_8) AT=220.025n

.meas tran vdout0_9ck430 FIND v(dout0_9) AT=220.025n

.meas tran vdout0_10ck430 FIND v(dout0_10) AT=220.025n

.meas tran vdout0_11ck430 FIND v(dout0_11) AT=220.025n

.meas tran vdout0_12ck430 FIND v(dout0_12) AT=220.025n

.meas tran vdout0_13ck430 FIND v(dout0_13) AT=220.025n

.meas tran vdout0_14ck430 FIND v(dout0_14) AT=220.025n

.meas tran vdout0_15ck430 FIND v(dout0_15) AT=220.025n

.meas tran vdout0_16ck430 FIND v(dout0_16) AT=220.025n

.meas tran vdout0_17ck430 FIND v(dout0_17) AT=220.025n

.meas tran vdout0_18ck430 FIND v(dout0_18) AT=220.025n

.meas tran vdout0_19ck430 FIND v(dout0_19) AT=220.025n

.meas tran vdout0_20ck430 FIND v(dout0_20) AT=220.025n

.meas tran vdout0_21ck430 FIND v(dout0_21) AT=220.025n

.meas tran vdout0_22ck430 FIND v(dout0_22) AT=220.025n

.meas tran vdout0_23ck430 FIND v(dout0_23) AT=220.025n

.meas tran vdout0_24ck430 FIND v(dout0_24) AT=220.025n

.meas tran vdout0_25ck430 FIND v(dout0_25) AT=220.025n

.meas tran vdout0_26ck430 FIND v(dout0_26) AT=220.025n

.meas tran vdout0_27ck430 FIND v(dout0_27) AT=220.025n

.meas tran vdout0_28ck430 FIND v(dout0_28) AT=220.025n

.meas tran vdout0_29ck430 FIND v(dout0_29) AT=220.025n

.meas tran vdout0_30ck430 FIND v(dout0_30) AT=220.025n

.meas tran vdout0_31ck430 FIND v(dout0_31) AT=220.025n

.meas tran vdout0_0ck450 FIND v(dout0_0) AT=230.025n

.meas tran vdout0_1ck450 FIND v(dout0_1) AT=230.025n

.meas tran vdout0_2ck450 FIND v(dout0_2) AT=230.025n

.meas tran vdout0_3ck450 FIND v(dout0_3) AT=230.025n

.meas tran vdout0_4ck450 FIND v(dout0_4) AT=230.025n

.meas tran vdout0_5ck450 FIND v(dout0_5) AT=230.025n

.meas tran vdout0_6ck450 FIND v(dout0_6) AT=230.025n

.meas tran vdout0_7ck450 FIND v(dout0_7) AT=230.025n

.meas tran vdout0_8ck450 FIND v(dout0_8) AT=230.025n

.meas tran vdout0_9ck450 FIND v(dout0_9) AT=230.025n

.meas tran vdout0_10ck450 FIND v(dout0_10) AT=230.025n

.meas tran vdout0_11ck450 FIND v(dout0_11) AT=230.025n

.meas tran vdout0_12ck450 FIND v(dout0_12) AT=230.025n

.meas tran vdout0_13ck450 FIND v(dout0_13) AT=230.025n

.meas tran vdout0_14ck450 FIND v(dout0_14) AT=230.025n

.meas tran vdout0_15ck450 FIND v(dout0_15) AT=230.025n

.meas tran vdout0_16ck450 FIND v(dout0_16) AT=230.025n

.meas tran vdout0_17ck450 FIND v(dout0_17) AT=230.025n

.meas tran vdout0_18ck450 FIND v(dout0_18) AT=230.025n

.meas tran vdout0_19ck450 FIND v(dout0_19) AT=230.025n

.meas tran vdout0_20ck450 FIND v(dout0_20) AT=230.025n

.meas tran vdout0_21ck450 FIND v(dout0_21) AT=230.025n

.meas tran vdout0_22ck450 FIND v(dout0_22) AT=230.025n

.meas tran vdout0_23ck450 FIND v(dout0_23) AT=230.025n

.meas tran vdout0_24ck450 FIND v(dout0_24) AT=230.025n

.meas tran vdout0_25ck450 FIND v(dout0_25) AT=230.025n

.meas tran vdout0_26ck450 FIND v(dout0_26) AT=230.025n

.meas tran vdout0_27ck450 FIND v(dout0_27) AT=230.025n

.meas tran vdout0_28ck450 FIND v(dout0_28) AT=230.025n

.meas tran vdout0_29ck450 FIND v(dout0_29) AT=230.025n

.meas tran vdout0_30ck450 FIND v(dout0_30) AT=230.025n

.meas tran vdout0_31ck450 FIND v(dout0_31) AT=230.025n

.meas tran vdout0_0ck530 FIND v(dout0_0) AT=270.025n

.meas tran vdout0_1ck530 FIND v(dout0_1) AT=270.025n

.meas tran vdout0_2ck530 FIND v(dout0_2) AT=270.025n

.meas tran vdout0_3ck530 FIND v(dout0_3) AT=270.025n

.meas tran vdout0_4ck530 FIND v(dout0_4) AT=270.025n

.meas tran vdout0_5ck530 FIND v(dout0_5) AT=270.025n

.meas tran vdout0_6ck530 FIND v(dout0_6) AT=270.025n

.meas tran vdout0_7ck530 FIND v(dout0_7) AT=270.025n

.meas tran vdout0_8ck530 FIND v(dout0_8) AT=270.025n

.meas tran vdout0_9ck530 FIND v(dout0_9) AT=270.025n

.meas tran vdout0_10ck530 FIND v(dout0_10) AT=270.025n

.meas tran vdout0_11ck530 FIND v(dout0_11) AT=270.025n

.meas tran vdout0_12ck530 FIND v(dout0_12) AT=270.025n

.meas tran vdout0_13ck530 FIND v(dout0_13) AT=270.025n

.meas tran vdout0_14ck530 FIND v(dout0_14) AT=270.025n

.meas tran vdout0_15ck530 FIND v(dout0_15) AT=270.025n

.meas tran vdout0_16ck530 FIND v(dout0_16) AT=270.025n

.meas tran vdout0_17ck530 FIND v(dout0_17) AT=270.025n

.meas tran vdout0_18ck530 FIND v(dout0_18) AT=270.025n

.meas tran vdout0_19ck530 FIND v(dout0_19) AT=270.025n

.meas tran vdout0_20ck530 FIND v(dout0_20) AT=270.025n

.meas tran vdout0_21ck530 FIND v(dout0_21) AT=270.025n

.meas tran vdout0_22ck530 FIND v(dout0_22) AT=270.025n

.meas tran vdout0_23ck530 FIND v(dout0_23) AT=270.025n

.meas tran vdout0_24ck530 FIND v(dout0_24) AT=270.025n

.meas tran vdout0_25ck530 FIND v(dout0_25) AT=270.025n

.meas tran vdout0_26ck530 FIND v(dout0_26) AT=270.025n

.meas tran vdout0_27ck530 FIND v(dout0_27) AT=270.025n

.meas tran vdout0_28ck530 FIND v(dout0_28) AT=270.025n

.meas tran vdout0_29ck530 FIND v(dout0_29) AT=270.025n

.meas tran vdout0_30ck530 FIND v(dout0_30) AT=270.025n

.meas tran vdout0_31ck530 FIND v(dout0_31) AT=270.025n

.meas tran vdout0_0ck550 FIND v(dout0_0) AT=280.025n

.meas tran vdout0_1ck550 FIND v(dout0_1) AT=280.025n

.meas tran vdout0_2ck550 FIND v(dout0_2) AT=280.025n

.meas tran vdout0_3ck550 FIND v(dout0_3) AT=280.025n

.meas tran vdout0_4ck550 FIND v(dout0_4) AT=280.025n

.meas tran vdout0_5ck550 FIND v(dout0_5) AT=280.025n

.meas tran vdout0_6ck550 FIND v(dout0_6) AT=280.025n

.meas tran vdout0_7ck550 FIND v(dout0_7) AT=280.025n

.meas tran vdout0_8ck550 FIND v(dout0_8) AT=280.025n

.meas tran vdout0_9ck550 FIND v(dout0_9) AT=280.025n

.meas tran vdout0_10ck550 FIND v(dout0_10) AT=280.025n

.meas tran vdout0_11ck550 FIND v(dout0_11) AT=280.025n

.meas tran vdout0_12ck550 FIND v(dout0_12) AT=280.025n

.meas tran vdout0_13ck550 FIND v(dout0_13) AT=280.025n

.meas tran vdout0_14ck550 FIND v(dout0_14) AT=280.025n

.meas tran vdout0_15ck550 FIND v(dout0_15) AT=280.025n

.meas tran vdout0_16ck550 FIND v(dout0_16) AT=280.025n

.meas tran vdout0_17ck550 FIND v(dout0_17) AT=280.025n

.meas tran vdout0_18ck550 FIND v(dout0_18) AT=280.025n

.meas tran vdout0_19ck550 FIND v(dout0_19) AT=280.025n

.meas tran vdout0_20ck550 FIND v(dout0_20) AT=280.025n

.meas tran vdout0_21ck550 FIND v(dout0_21) AT=280.025n

.meas tran vdout0_22ck550 FIND v(dout0_22) AT=280.025n

.meas tran vdout0_23ck550 FIND v(dout0_23) AT=280.025n

.meas tran vdout0_24ck550 FIND v(dout0_24) AT=280.025n

.meas tran vdout0_25ck550 FIND v(dout0_25) AT=280.025n

.meas tran vdout0_26ck550 FIND v(dout0_26) AT=280.025n

.meas tran vdout0_27ck550 FIND v(dout0_27) AT=280.025n

.meas tran vdout0_28ck550 FIND v(dout0_28) AT=280.025n

.meas tran vdout0_29ck550 FIND v(dout0_29) AT=280.025n

.meas tran vdout0_30ck550 FIND v(dout0_30) AT=280.025n

.meas tran vdout0_31ck550 FIND v(dout0_31) AT=280.025n

.meas tran vdout0_0ck560 FIND v(dout0_0) AT=285.025n

.meas tran vdout0_1ck560 FIND v(dout0_1) AT=285.025n

.meas tran vdout0_2ck560 FIND v(dout0_2) AT=285.025n

.meas tran vdout0_3ck560 FIND v(dout0_3) AT=285.025n

.meas tran vdout0_4ck560 FIND v(dout0_4) AT=285.025n

.meas tran vdout0_5ck560 FIND v(dout0_5) AT=285.025n

.meas tran vdout0_6ck560 FIND v(dout0_6) AT=285.025n

.meas tran vdout0_7ck560 FIND v(dout0_7) AT=285.025n

.meas tran vdout0_8ck560 FIND v(dout0_8) AT=285.025n

.meas tran vdout0_9ck560 FIND v(dout0_9) AT=285.025n

.meas tran vdout0_10ck560 FIND v(dout0_10) AT=285.025n

.meas tran vdout0_11ck560 FIND v(dout0_11) AT=285.025n

.meas tran vdout0_12ck560 FIND v(dout0_12) AT=285.025n

.meas tran vdout0_13ck560 FIND v(dout0_13) AT=285.025n

.meas tran vdout0_14ck560 FIND v(dout0_14) AT=285.025n

.meas tran vdout0_15ck560 FIND v(dout0_15) AT=285.025n

.meas tran vdout0_16ck560 FIND v(dout0_16) AT=285.025n

.meas tran vdout0_17ck560 FIND v(dout0_17) AT=285.025n

.meas tran vdout0_18ck560 FIND v(dout0_18) AT=285.025n

.meas tran vdout0_19ck560 FIND v(dout0_19) AT=285.025n

.meas tran vdout0_20ck560 FIND v(dout0_20) AT=285.025n

.meas tran vdout0_21ck560 FIND v(dout0_21) AT=285.025n

.meas tran vdout0_22ck560 FIND v(dout0_22) AT=285.025n

.meas tran vdout0_23ck560 FIND v(dout0_23) AT=285.025n

.meas tran vdout0_24ck560 FIND v(dout0_24) AT=285.025n

.meas tran vdout0_25ck560 FIND v(dout0_25) AT=285.025n

.meas tran vdout0_26ck560 FIND v(dout0_26) AT=285.025n

.meas tran vdout0_27ck560 FIND v(dout0_27) AT=285.025n

.meas tran vdout0_28ck560 FIND v(dout0_28) AT=285.025n

.meas tran vdout0_29ck560 FIND v(dout0_29) AT=285.025n

.meas tran vdout0_30ck560 FIND v(dout0_30) AT=285.025n

.meas tran vdout0_31ck560 FIND v(dout0_31) AT=285.025n

.meas tran vdout0_0ck580 FIND v(dout0_0) AT=295.025n

.meas tran vdout0_1ck580 FIND v(dout0_1) AT=295.025n

.meas tran vdout0_2ck580 FIND v(dout0_2) AT=295.025n

.meas tran vdout0_3ck580 FIND v(dout0_3) AT=295.025n

.meas tran vdout0_4ck580 FIND v(dout0_4) AT=295.025n

.meas tran vdout0_5ck580 FIND v(dout0_5) AT=295.025n

.meas tran vdout0_6ck580 FIND v(dout0_6) AT=295.025n

.meas tran vdout0_7ck580 FIND v(dout0_7) AT=295.025n

.meas tran vdout0_8ck580 FIND v(dout0_8) AT=295.025n

.meas tran vdout0_9ck580 FIND v(dout0_9) AT=295.025n

.meas tran vdout0_10ck580 FIND v(dout0_10) AT=295.025n

.meas tran vdout0_11ck580 FIND v(dout0_11) AT=295.025n

.meas tran vdout0_12ck580 FIND v(dout0_12) AT=295.025n

.meas tran vdout0_13ck580 FIND v(dout0_13) AT=295.025n

.meas tran vdout0_14ck580 FIND v(dout0_14) AT=295.025n

.meas tran vdout0_15ck580 FIND v(dout0_15) AT=295.025n

.meas tran vdout0_16ck580 FIND v(dout0_16) AT=295.025n

.meas tran vdout0_17ck580 FIND v(dout0_17) AT=295.025n

.meas tran vdout0_18ck580 FIND v(dout0_18) AT=295.025n

.meas tran vdout0_19ck580 FIND v(dout0_19) AT=295.025n

.meas tran vdout0_20ck580 FIND v(dout0_20) AT=295.025n

.meas tran vdout0_21ck580 FIND v(dout0_21) AT=295.025n

.meas tran vdout0_22ck580 FIND v(dout0_22) AT=295.025n

.meas tran vdout0_23ck580 FIND v(dout0_23) AT=295.025n

.meas tran vdout0_24ck580 FIND v(dout0_24) AT=295.025n

.meas tran vdout0_25ck580 FIND v(dout0_25) AT=295.025n

.meas tran vdout0_26ck580 FIND v(dout0_26) AT=295.025n

.meas tran vdout0_27ck580 FIND v(dout0_27) AT=295.025n

.meas tran vdout0_28ck580 FIND v(dout0_28) AT=295.025n

.meas tran vdout0_29ck580 FIND v(dout0_29) AT=295.025n

.meas tran vdout0_30ck580 FIND v(dout0_30) AT=295.025n

.meas tran vdout0_31ck580 FIND v(dout0_31) AT=295.025n

.meas tran vdout0_0ck590 FIND v(dout0_0) AT=300.025n

.meas tran vdout0_1ck590 FIND v(dout0_1) AT=300.025n

.meas tran vdout0_2ck590 FIND v(dout0_2) AT=300.025n

.meas tran vdout0_3ck590 FIND v(dout0_3) AT=300.025n

.meas tran vdout0_4ck590 FIND v(dout0_4) AT=300.025n

.meas tran vdout0_5ck590 FIND v(dout0_5) AT=300.025n

.meas tran vdout0_6ck590 FIND v(dout0_6) AT=300.025n

.meas tran vdout0_7ck590 FIND v(dout0_7) AT=300.025n

.meas tran vdout0_8ck590 FIND v(dout0_8) AT=300.025n

.meas tran vdout0_9ck590 FIND v(dout0_9) AT=300.025n

.meas tran vdout0_10ck590 FIND v(dout0_10) AT=300.025n

.meas tran vdout0_11ck590 FIND v(dout0_11) AT=300.025n

.meas tran vdout0_12ck590 FIND v(dout0_12) AT=300.025n

.meas tran vdout0_13ck590 FIND v(dout0_13) AT=300.025n

.meas tran vdout0_14ck590 FIND v(dout0_14) AT=300.025n

.meas tran vdout0_15ck590 FIND v(dout0_15) AT=300.025n

.meas tran vdout0_16ck590 FIND v(dout0_16) AT=300.025n

.meas tran vdout0_17ck590 FIND v(dout0_17) AT=300.025n

.meas tran vdout0_18ck590 FIND v(dout0_18) AT=300.025n

.meas tran vdout0_19ck590 FIND v(dout0_19) AT=300.025n

.meas tran vdout0_20ck590 FIND v(dout0_20) AT=300.025n

.meas tran vdout0_21ck590 FIND v(dout0_21) AT=300.025n

.meas tran vdout0_22ck590 FIND v(dout0_22) AT=300.025n

.meas tran vdout0_23ck590 FIND v(dout0_23) AT=300.025n

.meas tran vdout0_24ck590 FIND v(dout0_24) AT=300.025n

.meas tran vdout0_25ck590 FIND v(dout0_25) AT=300.025n

.meas tran vdout0_26ck590 FIND v(dout0_26) AT=300.025n

.meas tran vdout0_27ck590 FIND v(dout0_27) AT=300.025n

.meas tran vdout0_28ck590 FIND v(dout0_28) AT=300.025n

.meas tran vdout0_29ck590 FIND v(dout0_29) AT=300.025n

.meas tran vdout0_30ck590 FIND v(dout0_30) AT=300.025n

.meas tran vdout0_31ck590 FIND v(dout0_31) AT=300.025n

.meas tran vdout0_0ck600 FIND v(dout0_0) AT=305.025n

.meas tran vdout0_1ck600 FIND v(dout0_1) AT=305.025n

.meas tran vdout0_2ck600 FIND v(dout0_2) AT=305.025n

.meas tran vdout0_3ck600 FIND v(dout0_3) AT=305.025n

.meas tran vdout0_4ck600 FIND v(dout0_4) AT=305.025n

.meas tran vdout0_5ck600 FIND v(dout0_5) AT=305.025n

.meas tran vdout0_6ck600 FIND v(dout0_6) AT=305.025n

.meas tran vdout0_7ck600 FIND v(dout0_7) AT=305.025n

.meas tran vdout0_8ck600 FIND v(dout0_8) AT=305.025n

.meas tran vdout0_9ck600 FIND v(dout0_9) AT=305.025n

.meas tran vdout0_10ck600 FIND v(dout0_10) AT=305.025n

.meas tran vdout0_11ck600 FIND v(dout0_11) AT=305.025n

.meas tran vdout0_12ck600 FIND v(dout0_12) AT=305.025n

.meas tran vdout0_13ck600 FIND v(dout0_13) AT=305.025n

.meas tran vdout0_14ck600 FIND v(dout0_14) AT=305.025n

.meas tran vdout0_15ck600 FIND v(dout0_15) AT=305.025n

.meas tran vdout0_16ck600 FIND v(dout0_16) AT=305.025n

.meas tran vdout0_17ck600 FIND v(dout0_17) AT=305.025n

.meas tran vdout0_18ck600 FIND v(dout0_18) AT=305.025n

.meas tran vdout0_19ck600 FIND v(dout0_19) AT=305.025n

.meas tran vdout0_20ck600 FIND v(dout0_20) AT=305.025n

.meas tran vdout0_21ck600 FIND v(dout0_21) AT=305.025n

.meas tran vdout0_22ck600 FIND v(dout0_22) AT=305.025n

.meas tran vdout0_23ck600 FIND v(dout0_23) AT=305.025n

.meas tran vdout0_24ck600 FIND v(dout0_24) AT=305.025n

.meas tran vdout0_25ck600 FIND v(dout0_25) AT=305.025n

.meas tran vdout0_26ck600 FIND v(dout0_26) AT=305.025n

.meas tran vdout0_27ck600 FIND v(dout0_27) AT=305.025n

.meas tran vdout0_28ck600 FIND v(dout0_28) AT=305.025n

.meas tran vdout0_29ck600 FIND v(dout0_29) AT=305.025n

.meas tran vdout0_30ck600 FIND v(dout0_30) AT=305.025n

.meas tran vdout0_31ck600 FIND v(dout0_31) AT=305.025n

.meas tran vdout0_0ck630 FIND v(dout0_0) AT=320.025n

.meas tran vdout0_1ck630 FIND v(dout0_1) AT=320.025n

.meas tran vdout0_2ck630 FIND v(dout0_2) AT=320.025n

.meas tran vdout0_3ck630 FIND v(dout0_3) AT=320.025n

.meas tran vdout0_4ck630 FIND v(dout0_4) AT=320.025n

.meas tran vdout0_5ck630 FIND v(dout0_5) AT=320.025n

.meas tran vdout0_6ck630 FIND v(dout0_6) AT=320.025n

.meas tran vdout0_7ck630 FIND v(dout0_7) AT=320.025n

.meas tran vdout0_8ck630 FIND v(dout0_8) AT=320.025n

.meas tran vdout0_9ck630 FIND v(dout0_9) AT=320.025n

.meas tran vdout0_10ck630 FIND v(dout0_10) AT=320.025n

.meas tran vdout0_11ck630 FIND v(dout0_11) AT=320.025n

.meas tran vdout0_12ck630 FIND v(dout0_12) AT=320.025n

.meas tran vdout0_13ck630 FIND v(dout0_13) AT=320.025n

.meas tran vdout0_14ck630 FIND v(dout0_14) AT=320.025n

.meas tran vdout0_15ck630 FIND v(dout0_15) AT=320.025n

.meas tran vdout0_16ck630 FIND v(dout0_16) AT=320.025n

.meas tran vdout0_17ck630 FIND v(dout0_17) AT=320.025n

.meas tran vdout0_18ck630 FIND v(dout0_18) AT=320.025n

.meas tran vdout0_19ck630 FIND v(dout0_19) AT=320.025n

.meas tran vdout0_20ck630 FIND v(dout0_20) AT=320.025n

.meas tran vdout0_21ck630 FIND v(dout0_21) AT=320.025n

.meas tran vdout0_22ck630 FIND v(dout0_22) AT=320.025n

.meas tran vdout0_23ck630 FIND v(dout0_23) AT=320.025n

.meas tran vdout0_24ck630 FIND v(dout0_24) AT=320.025n

.meas tran vdout0_25ck630 FIND v(dout0_25) AT=320.025n

.meas tran vdout0_26ck630 FIND v(dout0_26) AT=320.025n

.meas tran vdout0_27ck630 FIND v(dout0_27) AT=320.025n

.meas tran vdout0_28ck630 FIND v(dout0_28) AT=320.025n

.meas tran vdout0_29ck630 FIND v(dout0_29) AT=320.025n

.meas tran vdout0_30ck630 FIND v(dout0_30) AT=320.025n

.meas tran vdout0_31ck630 FIND v(dout0_31) AT=320.025n

.meas tran vdout0_0ck670 FIND v(dout0_0) AT=340.025n

.meas tran vdout0_1ck670 FIND v(dout0_1) AT=340.025n

.meas tran vdout0_2ck670 FIND v(dout0_2) AT=340.025n

.meas tran vdout0_3ck670 FIND v(dout0_3) AT=340.025n

.meas tran vdout0_4ck670 FIND v(dout0_4) AT=340.025n

.meas tran vdout0_5ck670 FIND v(dout0_5) AT=340.025n

.meas tran vdout0_6ck670 FIND v(dout0_6) AT=340.025n

.meas tran vdout0_7ck670 FIND v(dout0_7) AT=340.025n

.meas tran vdout0_8ck670 FIND v(dout0_8) AT=340.025n

.meas tran vdout0_9ck670 FIND v(dout0_9) AT=340.025n

.meas tran vdout0_10ck670 FIND v(dout0_10) AT=340.025n

.meas tran vdout0_11ck670 FIND v(dout0_11) AT=340.025n

.meas tran vdout0_12ck670 FIND v(dout0_12) AT=340.025n

.meas tran vdout0_13ck670 FIND v(dout0_13) AT=340.025n

.meas tran vdout0_14ck670 FIND v(dout0_14) AT=340.025n

.meas tran vdout0_15ck670 FIND v(dout0_15) AT=340.025n

.meas tran vdout0_16ck670 FIND v(dout0_16) AT=340.025n

.meas tran vdout0_17ck670 FIND v(dout0_17) AT=340.025n

.meas tran vdout0_18ck670 FIND v(dout0_18) AT=340.025n

.meas tran vdout0_19ck670 FIND v(dout0_19) AT=340.025n

.meas tran vdout0_20ck670 FIND v(dout0_20) AT=340.025n

.meas tran vdout0_21ck670 FIND v(dout0_21) AT=340.025n

.meas tran vdout0_22ck670 FIND v(dout0_22) AT=340.025n

.meas tran vdout0_23ck670 FIND v(dout0_23) AT=340.025n

.meas tran vdout0_24ck670 FIND v(dout0_24) AT=340.025n

.meas tran vdout0_25ck670 FIND v(dout0_25) AT=340.025n

.meas tran vdout0_26ck670 FIND v(dout0_26) AT=340.025n

.meas tran vdout0_27ck670 FIND v(dout0_27) AT=340.025n

.meas tran vdout0_28ck670 FIND v(dout0_28) AT=340.025n

.meas tran vdout0_29ck670 FIND v(dout0_29) AT=340.025n

.meas tran vdout0_30ck670 FIND v(dout0_30) AT=340.025n

.meas tran vdout0_31ck670 FIND v(dout0_31) AT=340.025n

.meas tran vdout0_0ck680 FIND v(dout0_0) AT=345.025n

.meas tran vdout0_1ck680 FIND v(dout0_1) AT=345.025n

.meas tran vdout0_2ck680 FIND v(dout0_2) AT=345.025n

.meas tran vdout0_3ck680 FIND v(dout0_3) AT=345.025n

.meas tran vdout0_4ck680 FIND v(dout0_4) AT=345.025n

.meas tran vdout0_5ck680 FIND v(dout0_5) AT=345.025n

.meas tran vdout0_6ck680 FIND v(dout0_6) AT=345.025n

.meas tran vdout0_7ck680 FIND v(dout0_7) AT=345.025n

.meas tran vdout0_8ck680 FIND v(dout0_8) AT=345.025n

.meas tran vdout0_9ck680 FIND v(dout0_9) AT=345.025n

.meas tran vdout0_10ck680 FIND v(dout0_10) AT=345.025n

.meas tran vdout0_11ck680 FIND v(dout0_11) AT=345.025n

.meas tran vdout0_12ck680 FIND v(dout0_12) AT=345.025n

.meas tran vdout0_13ck680 FIND v(dout0_13) AT=345.025n

.meas tran vdout0_14ck680 FIND v(dout0_14) AT=345.025n

.meas tran vdout0_15ck680 FIND v(dout0_15) AT=345.025n

.meas tran vdout0_16ck680 FIND v(dout0_16) AT=345.025n

.meas tran vdout0_17ck680 FIND v(dout0_17) AT=345.025n

.meas tran vdout0_18ck680 FIND v(dout0_18) AT=345.025n

.meas tran vdout0_19ck680 FIND v(dout0_19) AT=345.025n

.meas tran vdout0_20ck680 FIND v(dout0_20) AT=345.025n

.meas tran vdout0_21ck680 FIND v(dout0_21) AT=345.025n

.meas tran vdout0_22ck680 FIND v(dout0_22) AT=345.025n

.meas tran vdout0_23ck680 FIND v(dout0_23) AT=345.025n

.meas tran vdout0_24ck680 FIND v(dout0_24) AT=345.025n

.meas tran vdout0_25ck680 FIND v(dout0_25) AT=345.025n

.meas tran vdout0_26ck680 FIND v(dout0_26) AT=345.025n

.meas tran vdout0_27ck680 FIND v(dout0_27) AT=345.025n

.meas tran vdout0_28ck680 FIND v(dout0_28) AT=345.025n

.meas tran vdout0_29ck680 FIND v(dout0_29) AT=345.025n

.meas tran vdout0_30ck680 FIND v(dout0_30) AT=345.025n

.meas tran vdout0_31ck680 FIND v(dout0_31) AT=345.025n

.meas tran vdout0_0ck700 FIND v(dout0_0) AT=355.025n

.meas tran vdout0_1ck700 FIND v(dout0_1) AT=355.025n

.meas tran vdout0_2ck700 FIND v(dout0_2) AT=355.025n

.meas tran vdout0_3ck700 FIND v(dout0_3) AT=355.025n

.meas tran vdout0_4ck700 FIND v(dout0_4) AT=355.025n

.meas tran vdout0_5ck700 FIND v(dout0_5) AT=355.025n

.meas tran vdout0_6ck700 FIND v(dout0_6) AT=355.025n

.meas tran vdout0_7ck700 FIND v(dout0_7) AT=355.025n

.meas tran vdout0_8ck700 FIND v(dout0_8) AT=355.025n

.meas tran vdout0_9ck700 FIND v(dout0_9) AT=355.025n

.meas tran vdout0_10ck700 FIND v(dout0_10) AT=355.025n

.meas tran vdout0_11ck700 FIND v(dout0_11) AT=355.025n

.meas tran vdout0_12ck700 FIND v(dout0_12) AT=355.025n

.meas tran vdout0_13ck700 FIND v(dout0_13) AT=355.025n

.meas tran vdout0_14ck700 FIND v(dout0_14) AT=355.025n

.meas tran vdout0_15ck700 FIND v(dout0_15) AT=355.025n

.meas tran vdout0_16ck700 FIND v(dout0_16) AT=355.025n

.meas tran vdout0_17ck700 FIND v(dout0_17) AT=355.025n

.meas tran vdout0_18ck700 FIND v(dout0_18) AT=355.025n

.meas tran vdout0_19ck700 FIND v(dout0_19) AT=355.025n

.meas tran vdout0_20ck700 FIND v(dout0_20) AT=355.025n

.meas tran vdout0_21ck700 FIND v(dout0_21) AT=355.025n

.meas tran vdout0_22ck700 FIND v(dout0_22) AT=355.025n

.meas tran vdout0_23ck700 FIND v(dout0_23) AT=355.025n

.meas tran vdout0_24ck700 FIND v(dout0_24) AT=355.025n

.meas tran vdout0_25ck700 FIND v(dout0_25) AT=355.025n

.meas tran vdout0_26ck700 FIND v(dout0_26) AT=355.025n

.meas tran vdout0_27ck700 FIND v(dout0_27) AT=355.025n

.meas tran vdout0_28ck700 FIND v(dout0_28) AT=355.025n

.meas tran vdout0_29ck700 FIND v(dout0_29) AT=355.025n

.meas tran vdout0_30ck700 FIND v(dout0_30) AT=355.025n

.meas tran vdout0_31ck700 FIND v(dout0_31) AT=355.025n

.meas tran vdout0_0ck710 FIND v(dout0_0) AT=360.025n

.meas tran vdout0_1ck710 FIND v(dout0_1) AT=360.025n

.meas tran vdout0_2ck710 FIND v(dout0_2) AT=360.025n

.meas tran vdout0_3ck710 FIND v(dout0_3) AT=360.025n

.meas tran vdout0_4ck710 FIND v(dout0_4) AT=360.025n

.meas tran vdout0_5ck710 FIND v(dout0_5) AT=360.025n

.meas tran vdout0_6ck710 FIND v(dout0_6) AT=360.025n

.meas tran vdout0_7ck710 FIND v(dout0_7) AT=360.025n

.meas tran vdout0_8ck710 FIND v(dout0_8) AT=360.025n

.meas tran vdout0_9ck710 FIND v(dout0_9) AT=360.025n

.meas tran vdout0_10ck710 FIND v(dout0_10) AT=360.025n

.meas tran vdout0_11ck710 FIND v(dout0_11) AT=360.025n

.meas tran vdout0_12ck710 FIND v(dout0_12) AT=360.025n

.meas tran vdout0_13ck710 FIND v(dout0_13) AT=360.025n

.meas tran vdout0_14ck710 FIND v(dout0_14) AT=360.025n

.meas tran vdout0_15ck710 FIND v(dout0_15) AT=360.025n

.meas tran vdout0_16ck710 FIND v(dout0_16) AT=360.025n

.meas tran vdout0_17ck710 FIND v(dout0_17) AT=360.025n

.meas tran vdout0_18ck710 FIND v(dout0_18) AT=360.025n

.meas tran vdout0_19ck710 FIND v(dout0_19) AT=360.025n

.meas tran vdout0_20ck710 FIND v(dout0_20) AT=360.025n

.meas tran vdout0_21ck710 FIND v(dout0_21) AT=360.025n

.meas tran vdout0_22ck710 FIND v(dout0_22) AT=360.025n

.meas tran vdout0_23ck710 FIND v(dout0_23) AT=360.025n

.meas tran vdout0_24ck710 FIND v(dout0_24) AT=360.025n

.meas tran vdout0_25ck710 FIND v(dout0_25) AT=360.025n

.meas tran vdout0_26ck710 FIND v(dout0_26) AT=360.025n

.meas tran vdout0_27ck710 FIND v(dout0_27) AT=360.025n

.meas tran vdout0_28ck710 FIND v(dout0_28) AT=360.025n

.meas tran vdout0_29ck710 FIND v(dout0_29) AT=360.025n

.meas tran vdout0_30ck710 FIND v(dout0_30) AT=360.025n

.meas tran vdout0_31ck710 FIND v(dout0_31) AT=360.025n

.meas tran vdout0_0ck720 FIND v(dout0_0) AT=365.025n

.meas tran vdout0_1ck720 FIND v(dout0_1) AT=365.025n

.meas tran vdout0_2ck720 FIND v(dout0_2) AT=365.025n

.meas tran vdout0_3ck720 FIND v(dout0_3) AT=365.025n

.meas tran vdout0_4ck720 FIND v(dout0_4) AT=365.025n

.meas tran vdout0_5ck720 FIND v(dout0_5) AT=365.025n

.meas tran vdout0_6ck720 FIND v(dout0_6) AT=365.025n

.meas tran vdout0_7ck720 FIND v(dout0_7) AT=365.025n

.meas tran vdout0_8ck720 FIND v(dout0_8) AT=365.025n

.meas tran vdout0_9ck720 FIND v(dout0_9) AT=365.025n

.meas tran vdout0_10ck720 FIND v(dout0_10) AT=365.025n

.meas tran vdout0_11ck720 FIND v(dout0_11) AT=365.025n

.meas tran vdout0_12ck720 FIND v(dout0_12) AT=365.025n

.meas tran vdout0_13ck720 FIND v(dout0_13) AT=365.025n

.meas tran vdout0_14ck720 FIND v(dout0_14) AT=365.025n

.meas tran vdout0_15ck720 FIND v(dout0_15) AT=365.025n

.meas tran vdout0_16ck720 FIND v(dout0_16) AT=365.025n

.meas tran vdout0_17ck720 FIND v(dout0_17) AT=365.025n

.meas tran vdout0_18ck720 FIND v(dout0_18) AT=365.025n

.meas tran vdout0_19ck720 FIND v(dout0_19) AT=365.025n

.meas tran vdout0_20ck720 FIND v(dout0_20) AT=365.025n

.meas tran vdout0_21ck720 FIND v(dout0_21) AT=365.025n

.meas tran vdout0_22ck720 FIND v(dout0_22) AT=365.025n

.meas tran vdout0_23ck720 FIND v(dout0_23) AT=365.025n

.meas tran vdout0_24ck720 FIND v(dout0_24) AT=365.025n

.meas tran vdout0_25ck720 FIND v(dout0_25) AT=365.025n

.meas tran vdout0_26ck720 FIND v(dout0_26) AT=365.025n

.meas tran vdout0_27ck720 FIND v(dout0_27) AT=365.025n

.meas tran vdout0_28ck720 FIND v(dout0_28) AT=365.025n

.meas tran vdout0_29ck720 FIND v(dout0_29) AT=365.025n

.meas tran vdout0_30ck720 FIND v(dout0_30) AT=365.025n

.meas tran vdout0_31ck720 FIND v(dout0_31) AT=365.025n

.meas tran vdout0_0ck810 FIND v(dout0_0) AT=410.025n

.meas tran vdout0_1ck810 FIND v(dout0_1) AT=410.025n

.meas tran vdout0_2ck810 FIND v(dout0_2) AT=410.025n

.meas tran vdout0_3ck810 FIND v(dout0_3) AT=410.025n

.meas tran vdout0_4ck810 FIND v(dout0_4) AT=410.025n

.meas tran vdout0_5ck810 FIND v(dout0_5) AT=410.025n

.meas tran vdout0_6ck810 FIND v(dout0_6) AT=410.025n

.meas tran vdout0_7ck810 FIND v(dout0_7) AT=410.025n

.meas tran vdout0_8ck810 FIND v(dout0_8) AT=410.025n

.meas tran vdout0_9ck810 FIND v(dout0_9) AT=410.025n

.meas tran vdout0_10ck810 FIND v(dout0_10) AT=410.025n

.meas tran vdout0_11ck810 FIND v(dout0_11) AT=410.025n

.meas tran vdout0_12ck810 FIND v(dout0_12) AT=410.025n

.meas tran vdout0_13ck810 FIND v(dout0_13) AT=410.025n

.meas tran vdout0_14ck810 FIND v(dout0_14) AT=410.025n

.meas tran vdout0_15ck810 FIND v(dout0_15) AT=410.025n

.meas tran vdout0_16ck810 FIND v(dout0_16) AT=410.025n

.meas tran vdout0_17ck810 FIND v(dout0_17) AT=410.025n

.meas tran vdout0_18ck810 FIND v(dout0_18) AT=410.025n

.meas tran vdout0_19ck810 FIND v(dout0_19) AT=410.025n

.meas tran vdout0_20ck810 FIND v(dout0_20) AT=410.025n

.meas tran vdout0_21ck810 FIND v(dout0_21) AT=410.025n

.meas tran vdout0_22ck810 FIND v(dout0_22) AT=410.025n

.meas tran vdout0_23ck810 FIND v(dout0_23) AT=410.025n

.meas tran vdout0_24ck810 FIND v(dout0_24) AT=410.025n

.meas tran vdout0_25ck810 FIND v(dout0_25) AT=410.025n

.meas tran vdout0_26ck810 FIND v(dout0_26) AT=410.025n

.meas tran vdout0_27ck810 FIND v(dout0_27) AT=410.025n

.meas tran vdout0_28ck810 FIND v(dout0_28) AT=410.025n

.meas tran vdout0_29ck810 FIND v(dout0_29) AT=410.025n

.meas tran vdout0_30ck810 FIND v(dout0_30) AT=410.025n

.meas tran vdout0_31ck810 FIND v(dout0_31) AT=410.025n

.meas tran vdout0_0ck820 FIND v(dout0_0) AT=415.025n

.meas tran vdout0_1ck820 FIND v(dout0_1) AT=415.025n

.meas tran vdout0_2ck820 FIND v(dout0_2) AT=415.025n

.meas tran vdout0_3ck820 FIND v(dout0_3) AT=415.025n

.meas tran vdout0_4ck820 FIND v(dout0_4) AT=415.025n

.meas tran vdout0_5ck820 FIND v(dout0_5) AT=415.025n

.meas tran vdout0_6ck820 FIND v(dout0_6) AT=415.025n

.meas tran vdout0_7ck820 FIND v(dout0_7) AT=415.025n

.meas tran vdout0_8ck820 FIND v(dout0_8) AT=415.025n

.meas tran vdout0_9ck820 FIND v(dout0_9) AT=415.025n

.meas tran vdout0_10ck820 FIND v(dout0_10) AT=415.025n

.meas tran vdout0_11ck820 FIND v(dout0_11) AT=415.025n

.meas tran vdout0_12ck820 FIND v(dout0_12) AT=415.025n

.meas tran vdout0_13ck820 FIND v(dout0_13) AT=415.025n

.meas tran vdout0_14ck820 FIND v(dout0_14) AT=415.025n

.meas tran vdout0_15ck820 FIND v(dout0_15) AT=415.025n

.meas tran vdout0_16ck820 FIND v(dout0_16) AT=415.025n

.meas tran vdout0_17ck820 FIND v(dout0_17) AT=415.025n

.meas tran vdout0_18ck820 FIND v(dout0_18) AT=415.025n

.meas tran vdout0_19ck820 FIND v(dout0_19) AT=415.025n

.meas tran vdout0_20ck820 FIND v(dout0_20) AT=415.025n

.meas tran vdout0_21ck820 FIND v(dout0_21) AT=415.025n

.meas tran vdout0_22ck820 FIND v(dout0_22) AT=415.025n

.meas tran vdout0_23ck820 FIND v(dout0_23) AT=415.025n

.meas tran vdout0_24ck820 FIND v(dout0_24) AT=415.025n

.meas tran vdout0_25ck820 FIND v(dout0_25) AT=415.025n

.meas tran vdout0_26ck820 FIND v(dout0_26) AT=415.025n

.meas tran vdout0_27ck820 FIND v(dout0_27) AT=415.025n

.meas tran vdout0_28ck820 FIND v(dout0_28) AT=415.025n

.meas tran vdout0_29ck820 FIND v(dout0_29) AT=415.025n

.meas tran vdout0_30ck820 FIND v(dout0_30) AT=415.025n

.meas tran vdout0_31ck820 FIND v(dout0_31) AT=415.025n

.meas tran vdout0_0ck850 FIND v(dout0_0) AT=430.025n

.meas tran vdout0_1ck850 FIND v(dout0_1) AT=430.025n

.meas tran vdout0_2ck850 FIND v(dout0_2) AT=430.025n

.meas tran vdout0_3ck850 FIND v(dout0_3) AT=430.025n

.meas tran vdout0_4ck850 FIND v(dout0_4) AT=430.025n

.meas tran vdout0_5ck850 FIND v(dout0_5) AT=430.025n

.meas tran vdout0_6ck850 FIND v(dout0_6) AT=430.025n

.meas tran vdout0_7ck850 FIND v(dout0_7) AT=430.025n

.meas tran vdout0_8ck850 FIND v(dout0_8) AT=430.025n

.meas tran vdout0_9ck850 FIND v(dout0_9) AT=430.025n

.meas tran vdout0_10ck850 FIND v(dout0_10) AT=430.025n

.meas tran vdout0_11ck850 FIND v(dout0_11) AT=430.025n

.meas tran vdout0_12ck850 FIND v(dout0_12) AT=430.025n

.meas tran vdout0_13ck850 FIND v(dout0_13) AT=430.025n

.meas tran vdout0_14ck850 FIND v(dout0_14) AT=430.025n

.meas tran vdout0_15ck850 FIND v(dout0_15) AT=430.025n

.meas tran vdout0_16ck850 FIND v(dout0_16) AT=430.025n

.meas tran vdout0_17ck850 FIND v(dout0_17) AT=430.025n

.meas tran vdout0_18ck850 FIND v(dout0_18) AT=430.025n

.meas tran vdout0_19ck850 FIND v(dout0_19) AT=430.025n

.meas tran vdout0_20ck850 FIND v(dout0_20) AT=430.025n

.meas tran vdout0_21ck850 FIND v(dout0_21) AT=430.025n

.meas tran vdout0_22ck850 FIND v(dout0_22) AT=430.025n

.meas tran vdout0_23ck850 FIND v(dout0_23) AT=430.025n

.meas tran vdout0_24ck850 FIND v(dout0_24) AT=430.025n

.meas tran vdout0_25ck850 FIND v(dout0_25) AT=430.025n

.meas tran vdout0_26ck850 FIND v(dout0_26) AT=430.025n

.meas tran vdout0_27ck850 FIND v(dout0_27) AT=430.025n

.meas tran vdout0_28ck850 FIND v(dout0_28) AT=430.025n

.meas tran vdout0_29ck850 FIND v(dout0_29) AT=430.025n

.meas tran vdout0_30ck850 FIND v(dout0_30) AT=430.025n

.meas tran vdout0_31ck850 FIND v(dout0_31) AT=430.025n

.meas tran vdout0_0ck870 FIND v(dout0_0) AT=440.025n

.meas tran vdout0_1ck870 FIND v(dout0_1) AT=440.025n

.meas tran vdout0_2ck870 FIND v(dout0_2) AT=440.025n

.meas tran vdout0_3ck870 FIND v(dout0_3) AT=440.025n

.meas tran vdout0_4ck870 FIND v(dout0_4) AT=440.025n

.meas tran vdout0_5ck870 FIND v(dout0_5) AT=440.025n

.meas tran vdout0_6ck870 FIND v(dout0_6) AT=440.025n

.meas tran vdout0_7ck870 FIND v(dout0_7) AT=440.025n

.meas tran vdout0_8ck870 FIND v(dout0_8) AT=440.025n

.meas tran vdout0_9ck870 FIND v(dout0_9) AT=440.025n

.meas tran vdout0_10ck870 FIND v(dout0_10) AT=440.025n

.meas tran vdout0_11ck870 FIND v(dout0_11) AT=440.025n

.meas tran vdout0_12ck870 FIND v(dout0_12) AT=440.025n

.meas tran vdout0_13ck870 FIND v(dout0_13) AT=440.025n

.meas tran vdout0_14ck870 FIND v(dout0_14) AT=440.025n

.meas tran vdout0_15ck870 FIND v(dout0_15) AT=440.025n

.meas tran vdout0_16ck870 FIND v(dout0_16) AT=440.025n

.meas tran vdout0_17ck870 FIND v(dout0_17) AT=440.025n

.meas tran vdout0_18ck870 FIND v(dout0_18) AT=440.025n

.meas tran vdout0_19ck870 FIND v(dout0_19) AT=440.025n

.meas tran vdout0_20ck870 FIND v(dout0_20) AT=440.025n

.meas tran vdout0_21ck870 FIND v(dout0_21) AT=440.025n

.meas tran vdout0_22ck870 FIND v(dout0_22) AT=440.025n

.meas tran vdout0_23ck870 FIND v(dout0_23) AT=440.025n

.meas tran vdout0_24ck870 FIND v(dout0_24) AT=440.025n

.meas tran vdout0_25ck870 FIND v(dout0_25) AT=440.025n

.meas tran vdout0_26ck870 FIND v(dout0_26) AT=440.025n

.meas tran vdout0_27ck870 FIND v(dout0_27) AT=440.025n

.meas tran vdout0_28ck870 FIND v(dout0_28) AT=440.025n

.meas tran vdout0_29ck870 FIND v(dout0_29) AT=440.025n

.meas tran vdout0_30ck870 FIND v(dout0_30) AT=440.025n

.meas tran vdout0_31ck870 FIND v(dout0_31) AT=440.025n

.meas tran vdout0_0ck890 FIND v(dout0_0) AT=450.025n

.meas tran vdout0_1ck890 FIND v(dout0_1) AT=450.025n

.meas tran vdout0_2ck890 FIND v(dout0_2) AT=450.025n

.meas tran vdout0_3ck890 FIND v(dout0_3) AT=450.025n

.meas tran vdout0_4ck890 FIND v(dout0_4) AT=450.025n

.meas tran vdout0_5ck890 FIND v(dout0_5) AT=450.025n

.meas tran vdout0_6ck890 FIND v(dout0_6) AT=450.025n

.meas tran vdout0_7ck890 FIND v(dout0_7) AT=450.025n

.meas tran vdout0_8ck890 FIND v(dout0_8) AT=450.025n

.meas tran vdout0_9ck890 FIND v(dout0_9) AT=450.025n

.meas tran vdout0_10ck890 FIND v(dout0_10) AT=450.025n

.meas tran vdout0_11ck890 FIND v(dout0_11) AT=450.025n

.meas tran vdout0_12ck890 FIND v(dout0_12) AT=450.025n

.meas tran vdout0_13ck890 FIND v(dout0_13) AT=450.025n

.meas tran vdout0_14ck890 FIND v(dout0_14) AT=450.025n

.meas tran vdout0_15ck890 FIND v(dout0_15) AT=450.025n

.meas tran vdout0_16ck890 FIND v(dout0_16) AT=450.025n

.meas tran vdout0_17ck890 FIND v(dout0_17) AT=450.025n

.meas tran vdout0_18ck890 FIND v(dout0_18) AT=450.025n

.meas tran vdout0_19ck890 FIND v(dout0_19) AT=450.025n

.meas tran vdout0_20ck890 FIND v(dout0_20) AT=450.025n

.meas tran vdout0_21ck890 FIND v(dout0_21) AT=450.025n

.meas tran vdout0_22ck890 FIND v(dout0_22) AT=450.025n

.meas tran vdout0_23ck890 FIND v(dout0_23) AT=450.025n

.meas tran vdout0_24ck890 FIND v(dout0_24) AT=450.025n

.meas tran vdout0_25ck890 FIND v(dout0_25) AT=450.025n

.meas tran vdout0_26ck890 FIND v(dout0_26) AT=450.025n

.meas tran vdout0_27ck890 FIND v(dout0_27) AT=450.025n

.meas tran vdout0_28ck890 FIND v(dout0_28) AT=450.025n

.meas tran vdout0_29ck890 FIND v(dout0_29) AT=450.025n

.meas tran vdout0_30ck890 FIND v(dout0_30) AT=450.025n

.meas tran vdout0_31ck890 FIND v(dout0_31) AT=450.025n

.meas tran vdout0_0ck900 FIND v(dout0_0) AT=455.025n

.meas tran vdout0_1ck900 FIND v(dout0_1) AT=455.025n

.meas tran vdout0_2ck900 FIND v(dout0_2) AT=455.025n

.meas tran vdout0_3ck900 FIND v(dout0_3) AT=455.025n

.meas tran vdout0_4ck900 FIND v(dout0_4) AT=455.025n

.meas tran vdout0_5ck900 FIND v(dout0_5) AT=455.025n

.meas tran vdout0_6ck900 FIND v(dout0_6) AT=455.025n

.meas tran vdout0_7ck900 FIND v(dout0_7) AT=455.025n

.meas tran vdout0_8ck900 FIND v(dout0_8) AT=455.025n

.meas tran vdout0_9ck900 FIND v(dout0_9) AT=455.025n

.meas tran vdout0_10ck900 FIND v(dout0_10) AT=455.025n

.meas tran vdout0_11ck900 FIND v(dout0_11) AT=455.025n

.meas tran vdout0_12ck900 FIND v(dout0_12) AT=455.025n

.meas tran vdout0_13ck900 FIND v(dout0_13) AT=455.025n

.meas tran vdout0_14ck900 FIND v(dout0_14) AT=455.025n

.meas tran vdout0_15ck900 FIND v(dout0_15) AT=455.025n

.meas tran vdout0_16ck900 FIND v(dout0_16) AT=455.025n

.meas tran vdout0_17ck900 FIND v(dout0_17) AT=455.025n

.meas tran vdout0_18ck900 FIND v(dout0_18) AT=455.025n

.meas tran vdout0_19ck900 FIND v(dout0_19) AT=455.025n

.meas tran vdout0_20ck900 FIND v(dout0_20) AT=455.025n

.meas tran vdout0_21ck900 FIND v(dout0_21) AT=455.025n

.meas tran vdout0_22ck900 FIND v(dout0_22) AT=455.025n

.meas tran vdout0_23ck900 FIND v(dout0_23) AT=455.025n

.meas tran vdout0_24ck900 FIND v(dout0_24) AT=455.025n

.meas tran vdout0_25ck900 FIND v(dout0_25) AT=455.025n

.meas tran vdout0_26ck900 FIND v(dout0_26) AT=455.025n

.meas tran vdout0_27ck900 FIND v(dout0_27) AT=455.025n

.meas tran vdout0_28ck900 FIND v(dout0_28) AT=455.025n

.meas tran vdout0_29ck900 FIND v(dout0_29) AT=455.025n

.meas tran vdout0_30ck900 FIND v(dout0_30) AT=455.025n

.meas tran vdout0_31ck900 FIND v(dout0_31) AT=455.025n

.meas tran vdout0_0ck910 FIND v(dout0_0) AT=460.025n

.meas tran vdout0_1ck910 FIND v(dout0_1) AT=460.025n

.meas tran vdout0_2ck910 FIND v(dout0_2) AT=460.025n

.meas tran vdout0_3ck910 FIND v(dout0_3) AT=460.025n

.meas tran vdout0_4ck910 FIND v(dout0_4) AT=460.025n

.meas tran vdout0_5ck910 FIND v(dout0_5) AT=460.025n

.meas tran vdout0_6ck910 FIND v(dout0_6) AT=460.025n

.meas tran vdout0_7ck910 FIND v(dout0_7) AT=460.025n

.meas tran vdout0_8ck910 FIND v(dout0_8) AT=460.025n

.meas tran vdout0_9ck910 FIND v(dout0_9) AT=460.025n

.meas tran vdout0_10ck910 FIND v(dout0_10) AT=460.025n

.meas tran vdout0_11ck910 FIND v(dout0_11) AT=460.025n

.meas tran vdout0_12ck910 FIND v(dout0_12) AT=460.025n

.meas tran vdout0_13ck910 FIND v(dout0_13) AT=460.025n

.meas tran vdout0_14ck910 FIND v(dout0_14) AT=460.025n

.meas tran vdout0_15ck910 FIND v(dout0_15) AT=460.025n

.meas tran vdout0_16ck910 FIND v(dout0_16) AT=460.025n

.meas tran vdout0_17ck910 FIND v(dout0_17) AT=460.025n

.meas tran vdout0_18ck910 FIND v(dout0_18) AT=460.025n

.meas tran vdout0_19ck910 FIND v(dout0_19) AT=460.025n

.meas tran vdout0_20ck910 FIND v(dout0_20) AT=460.025n

.meas tran vdout0_21ck910 FIND v(dout0_21) AT=460.025n

.meas tran vdout0_22ck910 FIND v(dout0_22) AT=460.025n

.meas tran vdout0_23ck910 FIND v(dout0_23) AT=460.025n

.meas tran vdout0_24ck910 FIND v(dout0_24) AT=460.025n

.meas tran vdout0_25ck910 FIND v(dout0_25) AT=460.025n

.meas tran vdout0_26ck910 FIND v(dout0_26) AT=460.025n

.meas tran vdout0_27ck910 FIND v(dout0_27) AT=460.025n

.meas tran vdout0_28ck910 FIND v(dout0_28) AT=460.025n

.meas tran vdout0_29ck910 FIND v(dout0_29) AT=460.025n

.meas tran vdout0_30ck910 FIND v(dout0_30) AT=460.025n

.meas tran vdout0_31ck910 FIND v(dout0_31) AT=460.025n

.meas tran vdout0_0ck920 FIND v(dout0_0) AT=465.025n

.meas tran vdout0_1ck920 FIND v(dout0_1) AT=465.025n

.meas tran vdout0_2ck920 FIND v(dout0_2) AT=465.025n

.meas tran vdout0_3ck920 FIND v(dout0_3) AT=465.025n

.meas tran vdout0_4ck920 FIND v(dout0_4) AT=465.025n

.meas tran vdout0_5ck920 FIND v(dout0_5) AT=465.025n

.meas tran vdout0_6ck920 FIND v(dout0_6) AT=465.025n

.meas tran vdout0_7ck920 FIND v(dout0_7) AT=465.025n

.meas tran vdout0_8ck920 FIND v(dout0_8) AT=465.025n

.meas tran vdout0_9ck920 FIND v(dout0_9) AT=465.025n

.meas tran vdout0_10ck920 FIND v(dout0_10) AT=465.025n

.meas tran vdout0_11ck920 FIND v(dout0_11) AT=465.025n

.meas tran vdout0_12ck920 FIND v(dout0_12) AT=465.025n

.meas tran vdout0_13ck920 FIND v(dout0_13) AT=465.025n

.meas tran vdout0_14ck920 FIND v(dout0_14) AT=465.025n

.meas tran vdout0_15ck920 FIND v(dout0_15) AT=465.025n

.meas tran vdout0_16ck920 FIND v(dout0_16) AT=465.025n

.meas tran vdout0_17ck920 FIND v(dout0_17) AT=465.025n

.meas tran vdout0_18ck920 FIND v(dout0_18) AT=465.025n

.meas tran vdout0_19ck920 FIND v(dout0_19) AT=465.025n

.meas tran vdout0_20ck920 FIND v(dout0_20) AT=465.025n

.meas tran vdout0_21ck920 FIND v(dout0_21) AT=465.025n

.meas tran vdout0_22ck920 FIND v(dout0_22) AT=465.025n

.meas tran vdout0_23ck920 FIND v(dout0_23) AT=465.025n

.meas tran vdout0_24ck920 FIND v(dout0_24) AT=465.025n

.meas tran vdout0_25ck920 FIND v(dout0_25) AT=465.025n

.meas tran vdout0_26ck920 FIND v(dout0_26) AT=465.025n

.meas tran vdout0_27ck920 FIND v(dout0_27) AT=465.025n

.meas tran vdout0_28ck920 FIND v(dout0_28) AT=465.025n

.meas tran vdout0_29ck920 FIND v(dout0_29) AT=465.025n

.meas tran vdout0_30ck920 FIND v(dout0_30) AT=465.025n

.meas tran vdout0_31ck920 FIND v(dout0_31) AT=465.025n

.meas tran vdout0_0ck930 FIND v(dout0_0) AT=470.025n

.meas tran vdout0_1ck930 FIND v(dout0_1) AT=470.025n

.meas tran vdout0_2ck930 FIND v(dout0_2) AT=470.025n

.meas tran vdout0_3ck930 FIND v(dout0_3) AT=470.025n

.meas tran vdout0_4ck930 FIND v(dout0_4) AT=470.025n

.meas tran vdout0_5ck930 FIND v(dout0_5) AT=470.025n

.meas tran vdout0_6ck930 FIND v(dout0_6) AT=470.025n

.meas tran vdout0_7ck930 FIND v(dout0_7) AT=470.025n

.meas tran vdout0_8ck930 FIND v(dout0_8) AT=470.025n

.meas tran vdout0_9ck930 FIND v(dout0_9) AT=470.025n

.meas tran vdout0_10ck930 FIND v(dout0_10) AT=470.025n

.meas tran vdout0_11ck930 FIND v(dout0_11) AT=470.025n

.meas tran vdout0_12ck930 FIND v(dout0_12) AT=470.025n

.meas tran vdout0_13ck930 FIND v(dout0_13) AT=470.025n

.meas tran vdout0_14ck930 FIND v(dout0_14) AT=470.025n

.meas tran vdout0_15ck930 FIND v(dout0_15) AT=470.025n

.meas tran vdout0_16ck930 FIND v(dout0_16) AT=470.025n

.meas tran vdout0_17ck930 FIND v(dout0_17) AT=470.025n

.meas tran vdout0_18ck930 FIND v(dout0_18) AT=470.025n

.meas tran vdout0_19ck930 FIND v(dout0_19) AT=470.025n

.meas tran vdout0_20ck930 FIND v(dout0_20) AT=470.025n

.meas tran vdout0_21ck930 FIND v(dout0_21) AT=470.025n

.meas tran vdout0_22ck930 FIND v(dout0_22) AT=470.025n

.meas tran vdout0_23ck930 FIND v(dout0_23) AT=470.025n

.meas tran vdout0_24ck930 FIND v(dout0_24) AT=470.025n

.meas tran vdout0_25ck930 FIND v(dout0_25) AT=470.025n

.meas tran vdout0_26ck930 FIND v(dout0_26) AT=470.025n

.meas tran vdout0_27ck930 FIND v(dout0_27) AT=470.025n

.meas tran vdout0_28ck930 FIND v(dout0_28) AT=470.025n

.meas tran vdout0_29ck930 FIND v(dout0_29) AT=470.025n

.meas tran vdout0_30ck930 FIND v(dout0_30) AT=470.025n

.meas tran vdout0_31ck930 FIND v(dout0_31) AT=470.025n

.meas tran vdout0_0ck940 FIND v(dout0_0) AT=475.025n

.meas tran vdout0_1ck940 FIND v(dout0_1) AT=475.025n

.meas tran vdout0_2ck940 FIND v(dout0_2) AT=475.025n

.meas tran vdout0_3ck940 FIND v(dout0_3) AT=475.025n

.meas tran vdout0_4ck940 FIND v(dout0_4) AT=475.025n

.meas tran vdout0_5ck940 FIND v(dout0_5) AT=475.025n

.meas tran vdout0_6ck940 FIND v(dout0_6) AT=475.025n

.meas tran vdout0_7ck940 FIND v(dout0_7) AT=475.025n

.meas tran vdout0_8ck940 FIND v(dout0_8) AT=475.025n

.meas tran vdout0_9ck940 FIND v(dout0_9) AT=475.025n

.meas tran vdout0_10ck940 FIND v(dout0_10) AT=475.025n

.meas tran vdout0_11ck940 FIND v(dout0_11) AT=475.025n

.meas tran vdout0_12ck940 FIND v(dout0_12) AT=475.025n

.meas tran vdout0_13ck940 FIND v(dout0_13) AT=475.025n

.meas tran vdout0_14ck940 FIND v(dout0_14) AT=475.025n

.meas tran vdout0_15ck940 FIND v(dout0_15) AT=475.025n

.meas tran vdout0_16ck940 FIND v(dout0_16) AT=475.025n

.meas tran vdout0_17ck940 FIND v(dout0_17) AT=475.025n

.meas tran vdout0_18ck940 FIND v(dout0_18) AT=475.025n

.meas tran vdout0_19ck940 FIND v(dout0_19) AT=475.025n

.meas tran vdout0_20ck940 FIND v(dout0_20) AT=475.025n

.meas tran vdout0_21ck940 FIND v(dout0_21) AT=475.025n

.meas tran vdout0_22ck940 FIND v(dout0_22) AT=475.025n

.meas tran vdout0_23ck940 FIND v(dout0_23) AT=475.025n

.meas tran vdout0_24ck940 FIND v(dout0_24) AT=475.025n

.meas tran vdout0_25ck940 FIND v(dout0_25) AT=475.025n

.meas tran vdout0_26ck940 FIND v(dout0_26) AT=475.025n

.meas tran vdout0_27ck940 FIND v(dout0_27) AT=475.025n

.meas tran vdout0_28ck940 FIND v(dout0_28) AT=475.025n

.meas tran vdout0_29ck940 FIND v(dout0_29) AT=475.025n

.meas tran vdout0_30ck940 FIND v(dout0_30) AT=475.025n

.meas tran vdout0_31ck940 FIND v(dout0_31) AT=475.025n

.meas tran vdout0_0ck950 FIND v(dout0_0) AT=480.025n

.meas tran vdout0_1ck950 FIND v(dout0_1) AT=480.025n

.meas tran vdout0_2ck950 FIND v(dout0_2) AT=480.025n

.meas tran vdout0_3ck950 FIND v(dout0_3) AT=480.025n

.meas tran vdout0_4ck950 FIND v(dout0_4) AT=480.025n

.meas tran vdout0_5ck950 FIND v(dout0_5) AT=480.025n

.meas tran vdout0_6ck950 FIND v(dout0_6) AT=480.025n

.meas tran vdout0_7ck950 FIND v(dout0_7) AT=480.025n

.meas tran vdout0_8ck950 FIND v(dout0_8) AT=480.025n

.meas tran vdout0_9ck950 FIND v(dout0_9) AT=480.025n

.meas tran vdout0_10ck950 FIND v(dout0_10) AT=480.025n

.meas tran vdout0_11ck950 FIND v(dout0_11) AT=480.025n

.meas tran vdout0_12ck950 FIND v(dout0_12) AT=480.025n

.meas tran vdout0_13ck950 FIND v(dout0_13) AT=480.025n

.meas tran vdout0_14ck950 FIND v(dout0_14) AT=480.025n

.meas tran vdout0_15ck950 FIND v(dout0_15) AT=480.025n

.meas tran vdout0_16ck950 FIND v(dout0_16) AT=480.025n

.meas tran vdout0_17ck950 FIND v(dout0_17) AT=480.025n

.meas tran vdout0_18ck950 FIND v(dout0_18) AT=480.025n

.meas tran vdout0_19ck950 FIND v(dout0_19) AT=480.025n

.meas tran vdout0_20ck950 FIND v(dout0_20) AT=480.025n

.meas tran vdout0_21ck950 FIND v(dout0_21) AT=480.025n

.meas tran vdout0_22ck950 FIND v(dout0_22) AT=480.025n

.meas tran vdout0_23ck950 FIND v(dout0_23) AT=480.025n

.meas tran vdout0_24ck950 FIND v(dout0_24) AT=480.025n

.meas tran vdout0_25ck950 FIND v(dout0_25) AT=480.025n

.meas tran vdout0_26ck950 FIND v(dout0_26) AT=480.025n

.meas tran vdout0_27ck950 FIND v(dout0_27) AT=480.025n

.meas tran vdout0_28ck950 FIND v(dout0_28) AT=480.025n

.meas tran vdout0_29ck950 FIND v(dout0_29) AT=480.025n

.meas tran vdout0_30ck950 FIND v(dout0_30) AT=480.025n

.meas tran vdout0_31ck950 FIND v(dout0_31) AT=480.025n

.meas tran vdout0_0ck1000 FIND v(dout0_0) AT=505.025n

.meas tran vdout0_1ck1000 FIND v(dout0_1) AT=505.025n

.meas tran vdout0_2ck1000 FIND v(dout0_2) AT=505.025n

.meas tran vdout0_3ck1000 FIND v(dout0_3) AT=505.025n

.meas tran vdout0_4ck1000 FIND v(dout0_4) AT=505.025n

.meas tran vdout0_5ck1000 FIND v(dout0_5) AT=505.025n

.meas tran vdout0_6ck1000 FIND v(dout0_6) AT=505.025n

.meas tran vdout0_7ck1000 FIND v(dout0_7) AT=505.025n

.meas tran vdout0_8ck1000 FIND v(dout0_8) AT=505.025n

.meas tran vdout0_9ck1000 FIND v(dout0_9) AT=505.025n

.meas tran vdout0_10ck1000 FIND v(dout0_10) AT=505.025n

.meas tran vdout0_11ck1000 FIND v(dout0_11) AT=505.025n

.meas tran vdout0_12ck1000 FIND v(dout0_12) AT=505.025n

.meas tran vdout0_13ck1000 FIND v(dout0_13) AT=505.025n

.meas tran vdout0_14ck1000 FIND v(dout0_14) AT=505.025n

.meas tran vdout0_15ck1000 FIND v(dout0_15) AT=505.025n

.meas tran vdout0_16ck1000 FIND v(dout0_16) AT=505.025n

.meas tran vdout0_17ck1000 FIND v(dout0_17) AT=505.025n

.meas tran vdout0_18ck1000 FIND v(dout0_18) AT=505.025n

.meas tran vdout0_19ck1000 FIND v(dout0_19) AT=505.025n

.meas tran vdout0_20ck1000 FIND v(dout0_20) AT=505.025n

.meas tran vdout0_21ck1000 FIND v(dout0_21) AT=505.025n

.meas tran vdout0_22ck1000 FIND v(dout0_22) AT=505.025n

.meas tran vdout0_23ck1000 FIND v(dout0_23) AT=505.025n

.meas tran vdout0_24ck1000 FIND v(dout0_24) AT=505.025n

.meas tran vdout0_25ck1000 FIND v(dout0_25) AT=505.025n

.meas tran vdout0_26ck1000 FIND v(dout0_26) AT=505.025n

.meas tran vdout0_27ck1000 FIND v(dout0_27) AT=505.025n

.meas tran vdout0_28ck1000 FIND v(dout0_28) AT=505.025n

.meas tran vdout0_29ck1000 FIND v(dout0_29) AT=505.025n

.meas tran vdout0_30ck1000 FIND v(dout0_30) AT=505.025n

.meas tran vdout0_31ck1000 FIND v(dout0_31) AT=505.025n

.meas tran vdout0_0ck1010 FIND v(dout0_0) AT=510.025n

.meas tran vdout0_1ck1010 FIND v(dout0_1) AT=510.025n

.meas tran vdout0_2ck1010 FIND v(dout0_2) AT=510.025n

.meas tran vdout0_3ck1010 FIND v(dout0_3) AT=510.025n

.meas tran vdout0_4ck1010 FIND v(dout0_4) AT=510.025n

.meas tran vdout0_5ck1010 FIND v(dout0_5) AT=510.025n

.meas tran vdout0_6ck1010 FIND v(dout0_6) AT=510.025n

.meas tran vdout0_7ck1010 FIND v(dout0_7) AT=510.025n

.meas tran vdout0_8ck1010 FIND v(dout0_8) AT=510.025n

.meas tran vdout0_9ck1010 FIND v(dout0_9) AT=510.025n

.meas tran vdout0_10ck1010 FIND v(dout0_10) AT=510.025n

.meas tran vdout0_11ck1010 FIND v(dout0_11) AT=510.025n

.meas tran vdout0_12ck1010 FIND v(dout0_12) AT=510.025n

.meas tran vdout0_13ck1010 FIND v(dout0_13) AT=510.025n

.meas tran vdout0_14ck1010 FIND v(dout0_14) AT=510.025n

.meas tran vdout0_15ck1010 FIND v(dout0_15) AT=510.025n

.meas tran vdout0_16ck1010 FIND v(dout0_16) AT=510.025n

.meas tran vdout0_17ck1010 FIND v(dout0_17) AT=510.025n

.meas tran vdout0_18ck1010 FIND v(dout0_18) AT=510.025n

.meas tran vdout0_19ck1010 FIND v(dout0_19) AT=510.025n

.meas tran vdout0_20ck1010 FIND v(dout0_20) AT=510.025n

.meas tran vdout0_21ck1010 FIND v(dout0_21) AT=510.025n

.meas tran vdout0_22ck1010 FIND v(dout0_22) AT=510.025n

.meas tran vdout0_23ck1010 FIND v(dout0_23) AT=510.025n

.meas tran vdout0_24ck1010 FIND v(dout0_24) AT=510.025n

.meas tran vdout0_25ck1010 FIND v(dout0_25) AT=510.025n

.meas tran vdout0_26ck1010 FIND v(dout0_26) AT=510.025n

.meas tran vdout0_27ck1010 FIND v(dout0_27) AT=510.025n

.meas tran vdout0_28ck1010 FIND v(dout0_28) AT=510.025n

.meas tran vdout0_29ck1010 FIND v(dout0_29) AT=510.025n

.meas tran vdout0_30ck1010 FIND v(dout0_30) AT=510.025n

.meas tran vdout0_31ck1010 FIND v(dout0_31) AT=510.025n

.meas tran vdout0_0ck1020 FIND v(dout0_0) AT=515.025n

.meas tran vdout0_1ck1020 FIND v(dout0_1) AT=515.025n

.meas tran vdout0_2ck1020 FIND v(dout0_2) AT=515.025n

.meas tran vdout0_3ck1020 FIND v(dout0_3) AT=515.025n

.meas tran vdout0_4ck1020 FIND v(dout0_4) AT=515.025n

.meas tran vdout0_5ck1020 FIND v(dout0_5) AT=515.025n

.meas tran vdout0_6ck1020 FIND v(dout0_6) AT=515.025n

.meas tran vdout0_7ck1020 FIND v(dout0_7) AT=515.025n

.meas tran vdout0_8ck1020 FIND v(dout0_8) AT=515.025n

.meas tran vdout0_9ck1020 FIND v(dout0_9) AT=515.025n

.meas tran vdout0_10ck1020 FIND v(dout0_10) AT=515.025n

.meas tran vdout0_11ck1020 FIND v(dout0_11) AT=515.025n

.meas tran vdout0_12ck1020 FIND v(dout0_12) AT=515.025n

.meas tran vdout0_13ck1020 FIND v(dout0_13) AT=515.025n

.meas tran vdout0_14ck1020 FIND v(dout0_14) AT=515.025n

.meas tran vdout0_15ck1020 FIND v(dout0_15) AT=515.025n

.meas tran vdout0_16ck1020 FIND v(dout0_16) AT=515.025n

.meas tran vdout0_17ck1020 FIND v(dout0_17) AT=515.025n

.meas tran vdout0_18ck1020 FIND v(dout0_18) AT=515.025n

.meas tran vdout0_19ck1020 FIND v(dout0_19) AT=515.025n

.meas tran vdout0_20ck1020 FIND v(dout0_20) AT=515.025n

.meas tran vdout0_21ck1020 FIND v(dout0_21) AT=515.025n

.meas tran vdout0_22ck1020 FIND v(dout0_22) AT=515.025n

.meas tran vdout0_23ck1020 FIND v(dout0_23) AT=515.025n

.meas tran vdout0_24ck1020 FIND v(dout0_24) AT=515.025n

.meas tran vdout0_25ck1020 FIND v(dout0_25) AT=515.025n

.meas tran vdout0_26ck1020 FIND v(dout0_26) AT=515.025n

.meas tran vdout0_27ck1020 FIND v(dout0_27) AT=515.025n

.meas tran vdout0_28ck1020 FIND v(dout0_28) AT=515.025n

.meas tran vdout0_29ck1020 FIND v(dout0_29) AT=515.025n

.meas tran vdout0_30ck1020 FIND v(dout0_30) AT=515.025n

.meas tran vdout0_31ck1020 FIND v(dout0_31) AT=515.025n

.meas tran vdout0_0ck1120 FIND v(dout0_0) AT=565.025n

.meas tran vdout0_1ck1120 FIND v(dout0_1) AT=565.025n

.meas tran vdout0_2ck1120 FIND v(dout0_2) AT=565.025n

.meas tran vdout0_3ck1120 FIND v(dout0_3) AT=565.025n

.meas tran vdout0_4ck1120 FIND v(dout0_4) AT=565.025n

.meas tran vdout0_5ck1120 FIND v(dout0_5) AT=565.025n

.meas tran vdout0_6ck1120 FIND v(dout0_6) AT=565.025n

.meas tran vdout0_7ck1120 FIND v(dout0_7) AT=565.025n

.meas tran vdout0_8ck1120 FIND v(dout0_8) AT=565.025n

.meas tran vdout0_9ck1120 FIND v(dout0_9) AT=565.025n

.meas tran vdout0_10ck1120 FIND v(dout0_10) AT=565.025n

.meas tran vdout0_11ck1120 FIND v(dout0_11) AT=565.025n

.meas tran vdout0_12ck1120 FIND v(dout0_12) AT=565.025n

.meas tran vdout0_13ck1120 FIND v(dout0_13) AT=565.025n

.meas tran vdout0_14ck1120 FIND v(dout0_14) AT=565.025n

.meas tran vdout0_15ck1120 FIND v(dout0_15) AT=565.025n

.meas tran vdout0_16ck1120 FIND v(dout0_16) AT=565.025n

.meas tran vdout0_17ck1120 FIND v(dout0_17) AT=565.025n

.meas tran vdout0_18ck1120 FIND v(dout0_18) AT=565.025n

.meas tran vdout0_19ck1120 FIND v(dout0_19) AT=565.025n

.meas tran vdout0_20ck1120 FIND v(dout0_20) AT=565.025n

.meas tran vdout0_21ck1120 FIND v(dout0_21) AT=565.025n

.meas tran vdout0_22ck1120 FIND v(dout0_22) AT=565.025n

.meas tran vdout0_23ck1120 FIND v(dout0_23) AT=565.025n

.meas tran vdout0_24ck1120 FIND v(dout0_24) AT=565.025n

.meas tran vdout0_25ck1120 FIND v(dout0_25) AT=565.025n

.meas tran vdout0_26ck1120 FIND v(dout0_26) AT=565.025n

.meas tran vdout0_27ck1120 FIND v(dout0_27) AT=565.025n

.meas tran vdout0_28ck1120 FIND v(dout0_28) AT=565.025n

.meas tran vdout0_29ck1120 FIND v(dout0_29) AT=565.025n

.meas tran vdout0_30ck1120 FIND v(dout0_30) AT=565.025n

.meas tran vdout0_31ck1120 FIND v(dout0_31) AT=565.025n

.meas tran vdout0_0ck1130 FIND v(dout0_0) AT=570.025n

.meas tran vdout0_1ck1130 FIND v(dout0_1) AT=570.025n

.meas tran vdout0_2ck1130 FIND v(dout0_2) AT=570.025n

.meas tran vdout0_3ck1130 FIND v(dout0_3) AT=570.025n

.meas tran vdout0_4ck1130 FIND v(dout0_4) AT=570.025n

.meas tran vdout0_5ck1130 FIND v(dout0_5) AT=570.025n

.meas tran vdout0_6ck1130 FIND v(dout0_6) AT=570.025n

.meas tran vdout0_7ck1130 FIND v(dout0_7) AT=570.025n

.meas tran vdout0_8ck1130 FIND v(dout0_8) AT=570.025n

.meas tran vdout0_9ck1130 FIND v(dout0_9) AT=570.025n

.meas tran vdout0_10ck1130 FIND v(dout0_10) AT=570.025n

.meas tran vdout0_11ck1130 FIND v(dout0_11) AT=570.025n

.meas tran vdout0_12ck1130 FIND v(dout0_12) AT=570.025n

.meas tran vdout0_13ck1130 FIND v(dout0_13) AT=570.025n

.meas tran vdout0_14ck1130 FIND v(dout0_14) AT=570.025n

.meas tran vdout0_15ck1130 FIND v(dout0_15) AT=570.025n

.meas tran vdout0_16ck1130 FIND v(dout0_16) AT=570.025n

.meas tran vdout0_17ck1130 FIND v(dout0_17) AT=570.025n

.meas tran vdout0_18ck1130 FIND v(dout0_18) AT=570.025n

.meas tran vdout0_19ck1130 FIND v(dout0_19) AT=570.025n

.meas tran vdout0_20ck1130 FIND v(dout0_20) AT=570.025n

.meas tran vdout0_21ck1130 FIND v(dout0_21) AT=570.025n

.meas tran vdout0_22ck1130 FIND v(dout0_22) AT=570.025n

.meas tran vdout0_23ck1130 FIND v(dout0_23) AT=570.025n

.meas tran vdout0_24ck1130 FIND v(dout0_24) AT=570.025n

.meas tran vdout0_25ck1130 FIND v(dout0_25) AT=570.025n

.meas tran vdout0_26ck1130 FIND v(dout0_26) AT=570.025n

.meas tran vdout0_27ck1130 FIND v(dout0_27) AT=570.025n

.meas tran vdout0_28ck1130 FIND v(dout0_28) AT=570.025n

.meas tran vdout0_29ck1130 FIND v(dout0_29) AT=570.025n

.meas tran vdout0_30ck1130 FIND v(dout0_30) AT=570.025n

.meas tran vdout0_31ck1130 FIND v(dout0_31) AT=570.025n

.meas tran vdout0_0ck1160 FIND v(dout0_0) AT=585.025n

.meas tran vdout0_1ck1160 FIND v(dout0_1) AT=585.025n

.meas tran vdout0_2ck1160 FIND v(dout0_2) AT=585.025n

.meas tran vdout0_3ck1160 FIND v(dout0_3) AT=585.025n

.meas tran vdout0_4ck1160 FIND v(dout0_4) AT=585.025n

.meas tran vdout0_5ck1160 FIND v(dout0_5) AT=585.025n

.meas tran vdout0_6ck1160 FIND v(dout0_6) AT=585.025n

.meas tran vdout0_7ck1160 FIND v(dout0_7) AT=585.025n

.meas tran vdout0_8ck1160 FIND v(dout0_8) AT=585.025n

.meas tran vdout0_9ck1160 FIND v(dout0_9) AT=585.025n

.meas tran vdout0_10ck1160 FIND v(dout0_10) AT=585.025n

.meas tran vdout0_11ck1160 FIND v(dout0_11) AT=585.025n

.meas tran vdout0_12ck1160 FIND v(dout0_12) AT=585.025n

.meas tran vdout0_13ck1160 FIND v(dout0_13) AT=585.025n

.meas tran vdout0_14ck1160 FIND v(dout0_14) AT=585.025n

.meas tran vdout0_15ck1160 FIND v(dout0_15) AT=585.025n

.meas tran vdout0_16ck1160 FIND v(dout0_16) AT=585.025n

.meas tran vdout0_17ck1160 FIND v(dout0_17) AT=585.025n

.meas tran vdout0_18ck1160 FIND v(dout0_18) AT=585.025n

.meas tran vdout0_19ck1160 FIND v(dout0_19) AT=585.025n

.meas tran vdout0_20ck1160 FIND v(dout0_20) AT=585.025n

.meas tran vdout0_21ck1160 FIND v(dout0_21) AT=585.025n

.meas tran vdout0_22ck1160 FIND v(dout0_22) AT=585.025n

.meas tran vdout0_23ck1160 FIND v(dout0_23) AT=585.025n

.meas tran vdout0_24ck1160 FIND v(dout0_24) AT=585.025n

.meas tran vdout0_25ck1160 FIND v(dout0_25) AT=585.025n

.meas tran vdout0_26ck1160 FIND v(dout0_26) AT=585.025n

.meas tran vdout0_27ck1160 FIND v(dout0_27) AT=585.025n

.meas tran vdout0_28ck1160 FIND v(dout0_28) AT=585.025n

.meas tran vdout0_29ck1160 FIND v(dout0_29) AT=585.025n

.meas tran vdout0_30ck1160 FIND v(dout0_30) AT=585.025n

.meas tran vdout0_31ck1160 FIND v(dout0_31) AT=585.025n

.meas tran vdout0_0ck1190 FIND v(dout0_0) AT=600.025n

.meas tran vdout0_1ck1190 FIND v(dout0_1) AT=600.025n

.meas tran vdout0_2ck1190 FIND v(dout0_2) AT=600.025n

.meas tran vdout0_3ck1190 FIND v(dout0_3) AT=600.025n

.meas tran vdout0_4ck1190 FIND v(dout0_4) AT=600.025n

.meas tran vdout0_5ck1190 FIND v(dout0_5) AT=600.025n

.meas tran vdout0_6ck1190 FIND v(dout0_6) AT=600.025n

.meas tran vdout0_7ck1190 FIND v(dout0_7) AT=600.025n

.meas tran vdout0_8ck1190 FIND v(dout0_8) AT=600.025n

.meas tran vdout0_9ck1190 FIND v(dout0_9) AT=600.025n

.meas tran vdout0_10ck1190 FIND v(dout0_10) AT=600.025n

.meas tran vdout0_11ck1190 FIND v(dout0_11) AT=600.025n

.meas tran vdout0_12ck1190 FIND v(dout0_12) AT=600.025n

.meas tran vdout0_13ck1190 FIND v(dout0_13) AT=600.025n

.meas tran vdout0_14ck1190 FIND v(dout0_14) AT=600.025n

.meas tran vdout0_15ck1190 FIND v(dout0_15) AT=600.025n

.meas tran vdout0_16ck1190 FIND v(dout0_16) AT=600.025n

.meas tran vdout0_17ck1190 FIND v(dout0_17) AT=600.025n

.meas tran vdout0_18ck1190 FIND v(dout0_18) AT=600.025n

.meas tran vdout0_19ck1190 FIND v(dout0_19) AT=600.025n

.meas tran vdout0_20ck1190 FIND v(dout0_20) AT=600.025n

.meas tran vdout0_21ck1190 FIND v(dout0_21) AT=600.025n

.meas tran vdout0_22ck1190 FIND v(dout0_22) AT=600.025n

.meas tran vdout0_23ck1190 FIND v(dout0_23) AT=600.025n

.meas tran vdout0_24ck1190 FIND v(dout0_24) AT=600.025n

.meas tran vdout0_25ck1190 FIND v(dout0_25) AT=600.025n

.meas tran vdout0_26ck1190 FIND v(dout0_26) AT=600.025n

.meas tran vdout0_27ck1190 FIND v(dout0_27) AT=600.025n

.meas tran vdout0_28ck1190 FIND v(dout0_28) AT=600.025n

.meas tran vdout0_29ck1190 FIND v(dout0_29) AT=600.025n

.meas tran vdout0_30ck1190 FIND v(dout0_30) AT=600.025n

.meas tran vdout0_31ck1190 FIND v(dout0_31) AT=600.025n

.meas tran vdout0_0ck1210 FIND v(dout0_0) AT=610.025n

.meas tran vdout0_1ck1210 FIND v(dout0_1) AT=610.025n

.meas tran vdout0_2ck1210 FIND v(dout0_2) AT=610.025n

.meas tran vdout0_3ck1210 FIND v(dout0_3) AT=610.025n

.meas tran vdout0_4ck1210 FIND v(dout0_4) AT=610.025n

.meas tran vdout0_5ck1210 FIND v(dout0_5) AT=610.025n

.meas tran vdout0_6ck1210 FIND v(dout0_6) AT=610.025n

.meas tran vdout0_7ck1210 FIND v(dout0_7) AT=610.025n

.meas tran vdout0_8ck1210 FIND v(dout0_8) AT=610.025n

.meas tran vdout0_9ck1210 FIND v(dout0_9) AT=610.025n

.meas tran vdout0_10ck1210 FIND v(dout0_10) AT=610.025n

.meas tran vdout0_11ck1210 FIND v(dout0_11) AT=610.025n

.meas tran vdout0_12ck1210 FIND v(dout0_12) AT=610.025n

.meas tran vdout0_13ck1210 FIND v(dout0_13) AT=610.025n

.meas tran vdout0_14ck1210 FIND v(dout0_14) AT=610.025n

.meas tran vdout0_15ck1210 FIND v(dout0_15) AT=610.025n

.meas tran vdout0_16ck1210 FIND v(dout0_16) AT=610.025n

.meas tran vdout0_17ck1210 FIND v(dout0_17) AT=610.025n

.meas tran vdout0_18ck1210 FIND v(dout0_18) AT=610.025n

.meas tran vdout0_19ck1210 FIND v(dout0_19) AT=610.025n

.meas tran vdout0_20ck1210 FIND v(dout0_20) AT=610.025n

.meas tran vdout0_21ck1210 FIND v(dout0_21) AT=610.025n

.meas tran vdout0_22ck1210 FIND v(dout0_22) AT=610.025n

.meas tran vdout0_23ck1210 FIND v(dout0_23) AT=610.025n

.meas tran vdout0_24ck1210 FIND v(dout0_24) AT=610.025n

.meas tran vdout0_25ck1210 FIND v(dout0_25) AT=610.025n

.meas tran vdout0_26ck1210 FIND v(dout0_26) AT=610.025n

.meas tran vdout0_27ck1210 FIND v(dout0_27) AT=610.025n

.meas tran vdout0_28ck1210 FIND v(dout0_28) AT=610.025n

.meas tran vdout0_29ck1210 FIND v(dout0_29) AT=610.025n

.meas tran vdout0_30ck1210 FIND v(dout0_30) AT=610.025n

.meas tran vdout0_31ck1210 FIND v(dout0_31) AT=610.025n

.meas tran vdout0_0ck1220 FIND v(dout0_0) AT=615.025n

.meas tran vdout0_1ck1220 FIND v(dout0_1) AT=615.025n

.meas tran vdout0_2ck1220 FIND v(dout0_2) AT=615.025n

.meas tran vdout0_3ck1220 FIND v(dout0_3) AT=615.025n

.meas tran vdout0_4ck1220 FIND v(dout0_4) AT=615.025n

.meas tran vdout0_5ck1220 FIND v(dout0_5) AT=615.025n

.meas tran vdout0_6ck1220 FIND v(dout0_6) AT=615.025n

.meas tran vdout0_7ck1220 FIND v(dout0_7) AT=615.025n

.meas tran vdout0_8ck1220 FIND v(dout0_8) AT=615.025n

.meas tran vdout0_9ck1220 FIND v(dout0_9) AT=615.025n

.meas tran vdout0_10ck1220 FIND v(dout0_10) AT=615.025n

.meas tran vdout0_11ck1220 FIND v(dout0_11) AT=615.025n

.meas tran vdout0_12ck1220 FIND v(dout0_12) AT=615.025n

.meas tran vdout0_13ck1220 FIND v(dout0_13) AT=615.025n

.meas tran vdout0_14ck1220 FIND v(dout0_14) AT=615.025n

.meas tran vdout0_15ck1220 FIND v(dout0_15) AT=615.025n

.meas tran vdout0_16ck1220 FIND v(dout0_16) AT=615.025n

.meas tran vdout0_17ck1220 FIND v(dout0_17) AT=615.025n

.meas tran vdout0_18ck1220 FIND v(dout0_18) AT=615.025n

.meas tran vdout0_19ck1220 FIND v(dout0_19) AT=615.025n

.meas tran vdout0_20ck1220 FIND v(dout0_20) AT=615.025n

.meas tran vdout0_21ck1220 FIND v(dout0_21) AT=615.025n

.meas tran vdout0_22ck1220 FIND v(dout0_22) AT=615.025n

.meas tran vdout0_23ck1220 FIND v(dout0_23) AT=615.025n

.meas tran vdout0_24ck1220 FIND v(dout0_24) AT=615.025n

.meas tran vdout0_25ck1220 FIND v(dout0_25) AT=615.025n

.meas tran vdout0_26ck1220 FIND v(dout0_26) AT=615.025n

.meas tran vdout0_27ck1220 FIND v(dout0_27) AT=615.025n

.meas tran vdout0_28ck1220 FIND v(dout0_28) AT=615.025n

.meas tran vdout0_29ck1220 FIND v(dout0_29) AT=615.025n

.meas tran vdout0_30ck1220 FIND v(dout0_30) AT=615.025n

.meas tran vdout0_31ck1220 FIND v(dout0_31) AT=615.025n

.meas tran vdout0_0ck1250 FIND v(dout0_0) AT=630.025n

.meas tran vdout0_1ck1250 FIND v(dout0_1) AT=630.025n

.meas tran vdout0_2ck1250 FIND v(dout0_2) AT=630.025n

.meas tran vdout0_3ck1250 FIND v(dout0_3) AT=630.025n

.meas tran vdout0_4ck1250 FIND v(dout0_4) AT=630.025n

.meas tran vdout0_5ck1250 FIND v(dout0_5) AT=630.025n

.meas tran vdout0_6ck1250 FIND v(dout0_6) AT=630.025n

.meas tran vdout0_7ck1250 FIND v(dout0_7) AT=630.025n

.meas tran vdout0_8ck1250 FIND v(dout0_8) AT=630.025n

.meas tran vdout0_9ck1250 FIND v(dout0_9) AT=630.025n

.meas tran vdout0_10ck1250 FIND v(dout0_10) AT=630.025n

.meas tran vdout0_11ck1250 FIND v(dout0_11) AT=630.025n

.meas tran vdout0_12ck1250 FIND v(dout0_12) AT=630.025n

.meas tran vdout0_13ck1250 FIND v(dout0_13) AT=630.025n

.meas tran vdout0_14ck1250 FIND v(dout0_14) AT=630.025n

.meas tran vdout0_15ck1250 FIND v(dout0_15) AT=630.025n

.meas tran vdout0_16ck1250 FIND v(dout0_16) AT=630.025n

.meas tran vdout0_17ck1250 FIND v(dout0_17) AT=630.025n

.meas tran vdout0_18ck1250 FIND v(dout0_18) AT=630.025n

.meas tran vdout0_19ck1250 FIND v(dout0_19) AT=630.025n

.meas tran vdout0_20ck1250 FIND v(dout0_20) AT=630.025n

.meas tran vdout0_21ck1250 FIND v(dout0_21) AT=630.025n

.meas tran vdout0_22ck1250 FIND v(dout0_22) AT=630.025n

.meas tran vdout0_23ck1250 FIND v(dout0_23) AT=630.025n

.meas tran vdout0_24ck1250 FIND v(dout0_24) AT=630.025n

.meas tran vdout0_25ck1250 FIND v(dout0_25) AT=630.025n

.meas tran vdout0_26ck1250 FIND v(dout0_26) AT=630.025n

.meas tran vdout0_27ck1250 FIND v(dout0_27) AT=630.025n

.meas tran vdout0_28ck1250 FIND v(dout0_28) AT=630.025n

.meas tran vdout0_29ck1250 FIND v(dout0_29) AT=630.025n

.meas tran vdout0_30ck1250 FIND v(dout0_30) AT=630.025n

.meas tran vdout0_31ck1250 FIND v(dout0_31) AT=630.025n

.meas tran vdout0_0ck1260 FIND v(dout0_0) AT=635.025n

.meas tran vdout0_1ck1260 FIND v(dout0_1) AT=635.025n

.meas tran vdout0_2ck1260 FIND v(dout0_2) AT=635.025n

.meas tran vdout0_3ck1260 FIND v(dout0_3) AT=635.025n

.meas tran vdout0_4ck1260 FIND v(dout0_4) AT=635.025n

.meas tran vdout0_5ck1260 FIND v(dout0_5) AT=635.025n

.meas tran vdout0_6ck1260 FIND v(dout0_6) AT=635.025n

.meas tran vdout0_7ck1260 FIND v(dout0_7) AT=635.025n

.meas tran vdout0_8ck1260 FIND v(dout0_8) AT=635.025n

.meas tran vdout0_9ck1260 FIND v(dout0_9) AT=635.025n

.meas tran vdout0_10ck1260 FIND v(dout0_10) AT=635.025n

.meas tran vdout0_11ck1260 FIND v(dout0_11) AT=635.025n

.meas tran vdout0_12ck1260 FIND v(dout0_12) AT=635.025n

.meas tran vdout0_13ck1260 FIND v(dout0_13) AT=635.025n

.meas tran vdout0_14ck1260 FIND v(dout0_14) AT=635.025n

.meas tran vdout0_15ck1260 FIND v(dout0_15) AT=635.025n

.meas tran vdout0_16ck1260 FIND v(dout0_16) AT=635.025n

.meas tran vdout0_17ck1260 FIND v(dout0_17) AT=635.025n

.meas tran vdout0_18ck1260 FIND v(dout0_18) AT=635.025n

.meas tran vdout0_19ck1260 FIND v(dout0_19) AT=635.025n

.meas tran vdout0_20ck1260 FIND v(dout0_20) AT=635.025n

.meas tran vdout0_21ck1260 FIND v(dout0_21) AT=635.025n

.meas tran vdout0_22ck1260 FIND v(dout0_22) AT=635.025n

.meas tran vdout0_23ck1260 FIND v(dout0_23) AT=635.025n

.meas tran vdout0_24ck1260 FIND v(dout0_24) AT=635.025n

.meas tran vdout0_25ck1260 FIND v(dout0_25) AT=635.025n

.meas tran vdout0_26ck1260 FIND v(dout0_26) AT=635.025n

.meas tran vdout0_27ck1260 FIND v(dout0_27) AT=635.025n

.meas tran vdout0_28ck1260 FIND v(dout0_28) AT=635.025n

.meas tran vdout0_29ck1260 FIND v(dout0_29) AT=635.025n

.meas tran vdout0_30ck1260 FIND v(dout0_30) AT=635.025n

.meas tran vdout0_31ck1260 FIND v(dout0_31) AT=635.025n

.meas tran vdout0_0ck1270 FIND v(dout0_0) AT=640.025n

.meas tran vdout0_1ck1270 FIND v(dout0_1) AT=640.025n

.meas tran vdout0_2ck1270 FIND v(dout0_2) AT=640.025n

.meas tran vdout0_3ck1270 FIND v(dout0_3) AT=640.025n

.meas tran vdout0_4ck1270 FIND v(dout0_4) AT=640.025n

.meas tran vdout0_5ck1270 FIND v(dout0_5) AT=640.025n

.meas tran vdout0_6ck1270 FIND v(dout0_6) AT=640.025n

.meas tran vdout0_7ck1270 FIND v(dout0_7) AT=640.025n

.meas tran vdout0_8ck1270 FIND v(dout0_8) AT=640.025n

.meas tran vdout0_9ck1270 FIND v(dout0_9) AT=640.025n

.meas tran vdout0_10ck1270 FIND v(dout0_10) AT=640.025n

.meas tran vdout0_11ck1270 FIND v(dout0_11) AT=640.025n

.meas tran vdout0_12ck1270 FIND v(dout0_12) AT=640.025n

.meas tran vdout0_13ck1270 FIND v(dout0_13) AT=640.025n

.meas tran vdout0_14ck1270 FIND v(dout0_14) AT=640.025n

.meas tran vdout0_15ck1270 FIND v(dout0_15) AT=640.025n

.meas tran vdout0_16ck1270 FIND v(dout0_16) AT=640.025n

.meas tran vdout0_17ck1270 FIND v(dout0_17) AT=640.025n

.meas tran vdout0_18ck1270 FIND v(dout0_18) AT=640.025n

.meas tran vdout0_19ck1270 FIND v(dout0_19) AT=640.025n

.meas tran vdout0_20ck1270 FIND v(dout0_20) AT=640.025n

.meas tran vdout0_21ck1270 FIND v(dout0_21) AT=640.025n

.meas tran vdout0_22ck1270 FIND v(dout0_22) AT=640.025n

.meas tran vdout0_23ck1270 FIND v(dout0_23) AT=640.025n

.meas tran vdout0_24ck1270 FIND v(dout0_24) AT=640.025n

.meas tran vdout0_25ck1270 FIND v(dout0_25) AT=640.025n

.meas tran vdout0_26ck1270 FIND v(dout0_26) AT=640.025n

.meas tran vdout0_27ck1270 FIND v(dout0_27) AT=640.025n

.meas tran vdout0_28ck1270 FIND v(dout0_28) AT=640.025n

.meas tran vdout0_29ck1270 FIND v(dout0_29) AT=640.025n

.meas tran vdout0_30ck1270 FIND v(dout0_30) AT=640.025n

.meas tran vdout0_31ck1270 FIND v(dout0_31) AT=640.025n

.meas tran vdout0_0ck1280 FIND v(dout0_0) AT=645.025n

.meas tran vdout0_1ck1280 FIND v(dout0_1) AT=645.025n

.meas tran vdout0_2ck1280 FIND v(dout0_2) AT=645.025n

.meas tran vdout0_3ck1280 FIND v(dout0_3) AT=645.025n

.meas tran vdout0_4ck1280 FIND v(dout0_4) AT=645.025n

.meas tran vdout0_5ck1280 FIND v(dout0_5) AT=645.025n

.meas tran vdout0_6ck1280 FIND v(dout0_6) AT=645.025n

.meas tran vdout0_7ck1280 FIND v(dout0_7) AT=645.025n

.meas tran vdout0_8ck1280 FIND v(dout0_8) AT=645.025n

.meas tran vdout0_9ck1280 FIND v(dout0_9) AT=645.025n

.meas tran vdout0_10ck1280 FIND v(dout0_10) AT=645.025n

.meas tran vdout0_11ck1280 FIND v(dout0_11) AT=645.025n

.meas tran vdout0_12ck1280 FIND v(dout0_12) AT=645.025n

.meas tran vdout0_13ck1280 FIND v(dout0_13) AT=645.025n

.meas tran vdout0_14ck1280 FIND v(dout0_14) AT=645.025n

.meas tran vdout0_15ck1280 FIND v(dout0_15) AT=645.025n

.meas tran vdout0_16ck1280 FIND v(dout0_16) AT=645.025n

.meas tran vdout0_17ck1280 FIND v(dout0_17) AT=645.025n

.meas tran vdout0_18ck1280 FIND v(dout0_18) AT=645.025n

.meas tran vdout0_19ck1280 FIND v(dout0_19) AT=645.025n

.meas tran vdout0_20ck1280 FIND v(dout0_20) AT=645.025n

.meas tran vdout0_21ck1280 FIND v(dout0_21) AT=645.025n

.meas tran vdout0_22ck1280 FIND v(dout0_22) AT=645.025n

.meas tran vdout0_23ck1280 FIND v(dout0_23) AT=645.025n

.meas tran vdout0_24ck1280 FIND v(dout0_24) AT=645.025n

.meas tran vdout0_25ck1280 FIND v(dout0_25) AT=645.025n

.meas tran vdout0_26ck1280 FIND v(dout0_26) AT=645.025n

.meas tran vdout0_27ck1280 FIND v(dout0_27) AT=645.025n

.meas tran vdout0_28ck1280 FIND v(dout0_28) AT=645.025n

.meas tran vdout0_29ck1280 FIND v(dout0_29) AT=645.025n

.meas tran vdout0_30ck1280 FIND v(dout0_30) AT=645.025n

.meas tran vdout0_31ck1280 FIND v(dout0_31) AT=645.025n

.meas tran vdout0_0ck1290 FIND v(dout0_0) AT=650.025n

.meas tran vdout0_1ck1290 FIND v(dout0_1) AT=650.025n

.meas tran vdout0_2ck1290 FIND v(dout0_2) AT=650.025n

.meas tran vdout0_3ck1290 FIND v(dout0_3) AT=650.025n

.meas tran vdout0_4ck1290 FIND v(dout0_4) AT=650.025n

.meas tran vdout0_5ck1290 FIND v(dout0_5) AT=650.025n

.meas tran vdout0_6ck1290 FIND v(dout0_6) AT=650.025n

.meas tran vdout0_7ck1290 FIND v(dout0_7) AT=650.025n

.meas tran vdout0_8ck1290 FIND v(dout0_8) AT=650.025n

.meas tran vdout0_9ck1290 FIND v(dout0_9) AT=650.025n

.meas tran vdout0_10ck1290 FIND v(dout0_10) AT=650.025n

.meas tran vdout0_11ck1290 FIND v(dout0_11) AT=650.025n

.meas tran vdout0_12ck1290 FIND v(dout0_12) AT=650.025n

.meas tran vdout0_13ck1290 FIND v(dout0_13) AT=650.025n

.meas tran vdout0_14ck1290 FIND v(dout0_14) AT=650.025n

.meas tran vdout0_15ck1290 FIND v(dout0_15) AT=650.025n

.meas tran vdout0_16ck1290 FIND v(dout0_16) AT=650.025n

.meas tran vdout0_17ck1290 FIND v(dout0_17) AT=650.025n

.meas tran vdout0_18ck1290 FIND v(dout0_18) AT=650.025n

.meas tran vdout0_19ck1290 FIND v(dout0_19) AT=650.025n

.meas tran vdout0_20ck1290 FIND v(dout0_20) AT=650.025n

.meas tran vdout0_21ck1290 FIND v(dout0_21) AT=650.025n

.meas tran vdout0_22ck1290 FIND v(dout0_22) AT=650.025n

.meas tran vdout0_23ck1290 FIND v(dout0_23) AT=650.025n

.meas tran vdout0_24ck1290 FIND v(dout0_24) AT=650.025n

.meas tran vdout0_25ck1290 FIND v(dout0_25) AT=650.025n

.meas tran vdout0_26ck1290 FIND v(dout0_26) AT=650.025n

.meas tran vdout0_27ck1290 FIND v(dout0_27) AT=650.025n

.meas tran vdout0_28ck1290 FIND v(dout0_28) AT=650.025n

.meas tran vdout0_29ck1290 FIND v(dout0_29) AT=650.025n

.meas tran vdout0_30ck1290 FIND v(dout0_30) AT=650.025n

.meas tran vdout0_31ck1290 FIND v(dout0_31) AT=650.025n

.meas tran vdout0_0ck1330 FIND v(dout0_0) AT=670.025n

.meas tran vdout0_1ck1330 FIND v(dout0_1) AT=670.025n

.meas tran vdout0_2ck1330 FIND v(dout0_2) AT=670.025n

.meas tran vdout0_3ck1330 FIND v(dout0_3) AT=670.025n

.meas tran vdout0_4ck1330 FIND v(dout0_4) AT=670.025n

.meas tran vdout0_5ck1330 FIND v(dout0_5) AT=670.025n

.meas tran vdout0_6ck1330 FIND v(dout0_6) AT=670.025n

.meas tran vdout0_7ck1330 FIND v(dout0_7) AT=670.025n

.meas tran vdout0_8ck1330 FIND v(dout0_8) AT=670.025n

.meas tran vdout0_9ck1330 FIND v(dout0_9) AT=670.025n

.meas tran vdout0_10ck1330 FIND v(dout0_10) AT=670.025n

.meas tran vdout0_11ck1330 FIND v(dout0_11) AT=670.025n

.meas tran vdout0_12ck1330 FIND v(dout0_12) AT=670.025n

.meas tran vdout0_13ck1330 FIND v(dout0_13) AT=670.025n

.meas tran vdout0_14ck1330 FIND v(dout0_14) AT=670.025n

.meas tran vdout0_15ck1330 FIND v(dout0_15) AT=670.025n

.meas tran vdout0_16ck1330 FIND v(dout0_16) AT=670.025n

.meas tran vdout0_17ck1330 FIND v(dout0_17) AT=670.025n

.meas tran vdout0_18ck1330 FIND v(dout0_18) AT=670.025n

.meas tran vdout0_19ck1330 FIND v(dout0_19) AT=670.025n

.meas tran vdout0_20ck1330 FIND v(dout0_20) AT=670.025n

.meas tran vdout0_21ck1330 FIND v(dout0_21) AT=670.025n

.meas tran vdout0_22ck1330 FIND v(dout0_22) AT=670.025n

.meas tran vdout0_23ck1330 FIND v(dout0_23) AT=670.025n

.meas tran vdout0_24ck1330 FIND v(dout0_24) AT=670.025n

.meas tran vdout0_25ck1330 FIND v(dout0_25) AT=670.025n

.meas tran vdout0_26ck1330 FIND v(dout0_26) AT=670.025n

.meas tran vdout0_27ck1330 FIND v(dout0_27) AT=670.025n

.meas tran vdout0_28ck1330 FIND v(dout0_28) AT=670.025n

.meas tran vdout0_29ck1330 FIND v(dout0_29) AT=670.025n

.meas tran vdout0_30ck1330 FIND v(dout0_30) AT=670.025n

.meas tran vdout0_31ck1330 FIND v(dout0_31) AT=670.025n

.meas tran vdout0_0ck1340 FIND v(dout0_0) AT=675.025n

.meas tran vdout0_1ck1340 FIND v(dout0_1) AT=675.025n

.meas tran vdout0_2ck1340 FIND v(dout0_2) AT=675.025n

.meas tran vdout0_3ck1340 FIND v(dout0_3) AT=675.025n

.meas tran vdout0_4ck1340 FIND v(dout0_4) AT=675.025n

.meas tran vdout0_5ck1340 FIND v(dout0_5) AT=675.025n

.meas tran vdout0_6ck1340 FIND v(dout0_6) AT=675.025n

.meas tran vdout0_7ck1340 FIND v(dout0_7) AT=675.025n

.meas tran vdout0_8ck1340 FIND v(dout0_8) AT=675.025n

.meas tran vdout0_9ck1340 FIND v(dout0_9) AT=675.025n

.meas tran vdout0_10ck1340 FIND v(dout0_10) AT=675.025n

.meas tran vdout0_11ck1340 FIND v(dout0_11) AT=675.025n

.meas tran vdout0_12ck1340 FIND v(dout0_12) AT=675.025n

.meas tran vdout0_13ck1340 FIND v(dout0_13) AT=675.025n

.meas tran vdout0_14ck1340 FIND v(dout0_14) AT=675.025n

.meas tran vdout0_15ck1340 FIND v(dout0_15) AT=675.025n

.meas tran vdout0_16ck1340 FIND v(dout0_16) AT=675.025n

.meas tran vdout0_17ck1340 FIND v(dout0_17) AT=675.025n

.meas tran vdout0_18ck1340 FIND v(dout0_18) AT=675.025n

.meas tran vdout0_19ck1340 FIND v(dout0_19) AT=675.025n

.meas tran vdout0_20ck1340 FIND v(dout0_20) AT=675.025n

.meas tran vdout0_21ck1340 FIND v(dout0_21) AT=675.025n

.meas tran vdout0_22ck1340 FIND v(dout0_22) AT=675.025n

.meas tran vdout0_23ck1340 FIND v(dout0_23) AT=675.025n

.meas tran vdout0_24ck1340 FIND v(dout0_24) AT=675.025n

.meas tran vdout0_25ck1340 FIND v(dout0_25) AT=675.025n

.meas tran vdout0_26ck1340 FIND v(dout0_26) AT=675.025n

.meas tran vdout0_27ck1340 FIND v(dout0_27) AT=675.025n

.meas tran vdout0_28ck1340 FIND v(dout0_28) AT=675.025n

.meas tran vdout0_29ck1340 FIND v(dout0_29) AT=675.025n

.meas tran vdout0_30ck1340 FIND v(dout0_30) AT=675.025n

.meas tran vdout0_31ck1340 FIND v(dout0_31) AT=675.025n

.meas tran vdout0_0ck1370 FIND v(dout0_0) AT=690.025n

.meas tran vdout0_1ck1370 FIND v(dout0_1) AT=690.025n

.meas tran vdout0_2ck1370 FIND v(dout0_2) AT=690.025n

.meas tran vdout0_3ck1370 FIND v(dout0_3) AT=690.025n

.meas tran vdout0_4ck1370 FIND v(dout0_4) AT=690.025n

.meas tran vdout0_5ck1370 FIND v(dout0_5) AT=690.025n

.meas tran vdout0_6ck1370 FIND v(dout0_6) AT=690.025n

.meas tran vdout0_7ck1370 FIND v(dout0_7) AT=690.025n

.meas tran vdout0_8ck1370 FIND v(dout0_8) AT=690.025n

.meas tran vdout0_9ck1370 FIND v(dout0_9) AT=690.025n

.meas tran vdout0_10ck1370 FIND v(dout0_10) AT=690.025n

.meas tran vdout0_11ck1370 FIND v(dout0_11) AT=690.025n

.meas tran vdout0_12ck1370 FIND v(dout0_12) AT=690.025n

.meas tran vdout0_13ck1370 FIND v(dout0_13) AT=690.025n

.meas tran vdout0_14ck1370 FIND v(dout0_14) AT=690.025n

.meas tran vdout0_15ck1370 FIND v(dout0_15) AT=690.025n

.meas tran vdout0_16ck1370 FIND v(dout0_16) AT=690.025n

.meas tran vdout0_17ck1370 FIND v(dout0_17) AT=690.025n

.meas tran vdout0_18ck1370 FIND v(dout0_18) AT=690.025n

.meas tran vdout0_19ck1370 FIND v(dout0_19) AT=690.025n

.meas tran vdout0_20ck1370 FIND v(dout0_20) AT=690.025n

.meas tran vdout0_21ck1370 FIND v(dout0_21) AT=690.025n

.meas tran vdout0_22ck1370 FIND v(dout0_22) AT=690.025n

.meas tran vdout0_23ck1370 FIND v(dout0_23) AT=690.025n

.meas tran vdout0_24ck1370 FIND v(dout0_24) AT=690.025n

.meas tran vdout0_25ck1370 FIND v(dout0_25) AT=690.025n

.meas tran vdout0_26ck1370 FIND v(dout0_26) AT=690.025n

.meas tran vdout0_27ck1370 FIND v(dout0_27) AT=690.025n

.meas tran vdout0_28ck1370 FIND v(dout0_28) AT=690.025n

.meas tran vdout0_29ck1370 FIND v(dout0_29) AT=690.025n

.meas tran vdout0_30ck1370 FIND v(dout0_30) AT=690.025n

.meas tran vdout0_31ck1370 FIND v(dout0_31) AT=690.025n

.meas tran vdout0_0ck1390 FIND v(dout0_0) AT=700.025n

.meas tran vdout0_1ck1390 FIND v(dout0_1) AT=700.025n

.meas tran vdout0_2ck1390 FIND v(dout0_2) AT=700.025n

.meas tran vdout0_3ck1390 FIND v(dout0_3) AT=700.025n

.meas tran vdout0_4ck1390 FIND v(dout0_4) AT=700.025n

.meas tran vdout0_5ck1390 FIND v(dout0_5) AT=700.025n

.meas tran vdout0_6ck1390 FIND v(dout0_6) AT=700.025n

.meas tran vdout0_7ck1390 FIND v(dout0_7) AT=700.025n

.meas tran vdout0_8ck1390 FIND v(dout0_8) AT=700.025n

.meas tran vdout0_9ck1390 FIND v(dout0_9) AT=700.025n

.meas tran vdout0_10ck1390 FIND v(dout0_10) AT=700.025n

.meas tran vdout0_11ck1390 FIND v(dout0_11) AT=700.025n

.meas tran vdout0_12ck1390 FIND v(dout0_12) AT=700.025n

.meas tran vdout0_13ck1390 FIND v(dout0_13) AT=700.025n

.meas tran vdout0_14ck1390 FIND v(dout0_14) AT=700.025n

.meas tran vdout0_15ck1390 FIND v(dout0_15) AT=700.025n

.meas tran vdout0_16ck1390 FIND v(dout0_16) AT=700.025n

.meas tran vdout0_17ck1390 FIND v(dout0_17) AT=700.025n

.meas tran vdout0_18ck1390 FIND v(dout0_18) AT=700.025n

.meas tran vdout0_19ck1390 FIND v(dout0_19) AT=700.025n

.meas tran vdout0_20ck1390 FIND v(dout0_20) AT=700.025n

.meas tran vdout0_21ck1390 FIND v(dout0_21) AT=700.025n

.meas tran vdout0_22ck1390 FIND v(dout0_22) AT=700.025n

.meas tran vdout0_23ck1390 FIND v(dout0_23) AT=700.025n

.meas tran vdout0_24ck1390 FIND v(dout0_24) AT=700.025n

.meas tran vdout0_25ck1390 FIND v(dout0_25) AT=700.025n

.meas tran vdout0_26ck1390 FIND v(dout0_26) AT=700.025n

.meas tran vdout0_27ck1390 FIND v(dout0_27) AT=700.025n

.meas tran vdout0_28ck1390 FIND v(dout0_28) AT=700.025n

.meas tran vdout0_29ck1390 FIND v(dout0_29) AT=700.025n

.meas tran vdout0_30ck1390 FIND v(dout0_30) AT=700.025n

.meas tran vdout0_31ck1390 FIND v(dout0_31) AT=700.025n

.meas tran vdout0_0ck1440 FIND v(dout0_0) AT=725.025n

.meas tran vdout0_1ck1440 FIND v(dout0_1) AT=725.025n

.meas tran vdout0_2ck1440 FIND v(dout0_2) AT=725.025n

.meas tran vdout0_3ck1440 FIND v(dout0_3) AT=725.025n

.meas tran vdout0_4ck1440 FIND v(dout0_4) AT=725.025n

.meas tran vdout0_5ck1440 FIND v(dout0_5) AT=725.025n

.meas tran vdout0_6ck1440 FIND v(dout0_6) AT=725.025n

.meas tran vdout0_7ck1440 FIND v(dout0_7) AT=725.025n

.meas tran vdout0_8ck1440 FIND v(dout0_8) AT=725.025n

.meas tran vdout0_9ck1440 FIND v(dout0_9) AT=725.025n

.meas tran vdout0_10ck1440 FIND v(dout0_10) AT=725.025n

.meas tran vdout0_11ck1440 FIND v(dout0_11) AT=725.025n

.meas tran vdout0_12ck1440 FIND v(dout0_12) AT=725.025n

.meas tran vdout0_13ck1440 FIND v(dout0_13) AT=725.025n

.meas tran vdout0_14ck1440 FIND v(dout0_14) AT=725.025n

.meas tran vdout0_15ck1440 FIND v(dout0_15) AT=725.025n

.meas tran vdout0_16ck1440 FIND v(dout0_16) AT=725.025n

.meas tran vdout0_17ck1440 FIND v(dout0_17) AT=725.025n

.meas tran vdout0_18ck1440 FIND v(dout0_18) AT=725.025n

.meas tran vdout0_19ck1440 FIND v(dout0_19) AT=725.025n

.meas tran vdout0_20ck1440 FIND v(dout0_20) AT=725.025n

.meas tran vdout0_21ck1440 FIND v(dout0_21) AT=725.025n

.meas tran vdout0_22ck1440 FIND v(dout0_22) AT=725.025n

.meas tran vdout0_23ck1440 FIND v(dout0_23) AT=725.025n

.meas tran vdout0_24ck1440 FIND v(dout0_24) AT=725.025n

.meas tran vdout0_25ck1440 FIND v(dout0_25) AT=725.025n

.meas tran vdout0_26ck1440 FIND v(dout0_26) AT=725.025n

.meas tran vdout0_27ck1440 FIND v(dout0_27) AT=725.025n

.meas tran vdout0_28ck1440 FIND v(dout0_28) AT=725.025n

.meas tran vdout0_29ck1440 FIND v(dout0_29) AT=725.025n

.meas tran vdout0_30ck1440 FIND v(dout0_30) AT=725.025n

.meas tran vdout0_31ck1440 FIND v(dout0_31) AT=725.025n

.meas tran vdout0_0ck1460 FIND v(dout0_0) AT=735.025n

.meas tran vdout0_1ck1460 FIND v(dout0_1) AT=735.025n

.meas tran vdout0_2ck1460 FIND v(dout0_2) AT=735.025n

.meas tran vdout0_3ck1460 FIND v(dout0_3) AT=735.025n

.meas tran vdout0_4ck1460 FIND v(dout0_4) AT=735.025n

.meas tran vdout0_5ck1460 FIND v(dout0_5) AT=735.025n

.meas tran vdout0_6ck1460 FIND v(dout0_6) AT=735.025n

.meas tran vdout0_7ck1460 FIND v(dout0_7) AT=735.025n

.meas tran vdout0_8ck1460 FIND v(dout0_8) AT=735.025n

.meas tran vdout0_9ck1460 FIND v(dout0_9) AT=735.025n

.meas tran vdout0_10ck1460 FIND v(dout0_10) AT=735.025n

.meas tran vdout0_11ck1460 FIND v(dout0_11) AT=735.025n

.meas tran vdout0_12ck1460 FIND v(dout0_12) AT=735.025n

.meas tran vdout0_13ck1460 FIND v(dout0_13) AT=735.025n

.meas tran vdout0_14ck1460 FIND v(dout0_14) AT=735.025n

.meas tran vdout0_15ck1460 FIND v(dout0_15) AT=735.025n

.meas tran vdout0_16ck1460 FIND v(dout0_16) AT=735.025n

.meas tran vdout0_17ck1460 FIND v(dout0_17) AT=735.025n

.meas tran vdout0_18ck1460 FIND v(dout0_18) AT=735.025n

.meas tran vdout0_19ck1460 FIND v(dout0_19) AT=735.025n

.meas tran vdout0_20ck1460 FIND v(dout0_20) AT=735.025n

.meas tran vdout0_21ck1460 FIND v(dout0_21) AT=735.025n

.meas tran vdout0_22ck1460 FIND v(dout0_22) AT=735.025n

.meas tran vdout0_23ck1460 FIND v(dout0_23) AT=735.025n

.meas tran vdout0_24ck1460 FIND v(dout0_24) AT=735.025n

.meas tran vdout0_25ck1460 FIND v(dout0_25) AT=735.025n

.meas tran vdout0_26ck1460 FIND v(dout0_26) AT=735.025n

.meas tran vdout0_27ck1460 FIND v(dout0_27) AT=735.025n

.meas tran vdout0_28ck1460 FIND v(dout0_28) AT=735.025n

.meas tran vdout0_29ck1460 FIND v(dout0_29) AT=735.025n

.meas tran vdout0_30ck1460 FIND v(dout0_30) AT=735.025n

.meas tran vdout0_31ck1460 FIND v(dout0_31) AT=735.025n

.meas tran vdout0_0ck1500 FIND v(dout0_0) AT=755.025n

.meas tran vdout0_1ck1500 FIND v(dout0_1) AT=755.025n

.meas tran vdout0_2ck1500 FIND v(dout0_2) AT=755.025n

.meas tran vdout0_3ck1500 FIND v(dout0_3) AT=755.025n

.meas tran vdout0_4ck1500 FIND v(dout0_4) AT=755.025n

.meas tran vdout0_5ck1500 FIND v(dout0_5) AT=755.025n

.meas tran vdout0_6ck1500 FIND v(dout0_6) AT=755.025n

.meas tran vdout0_7ck1500 FIND v(dout0_7) AT=755.025n

.meas tran vdout0_8ck1500 FIND v(dout0_8) AT=755.025n

.meas tran vdout0_9ck1500 FIND v(dout0_9) AT=755.025n

.meas tran vdout0_10ck1500 FIND v(dout0_10) AT=755.025n

.meas tran vdout0_11ck1500 FIND v(dout0_11) AT=755.025n

.meas tran vdout0_12ck1500 FIND v(dout0_12) AT=755.025n

.meas tran vdout0_13ck1500 FIND v(dout0_13) AT=755.025n

.meas tran vdout0_14ck1500 FIND v(dout0_14) AT=755.025n

.meas tran vdout0_15ck1500 FIND v(dout0_15) AT=755.025n

.meas tran vdout0_16ck1500 FIND v(dout0_16) AT=755.025n

.meas tran vdout0_17ck1500 FIND v(dout0_17) AT=755.025n

.meas tran vdout0_18ck1500 FIND v(dout0_18) AT=755.025n

.meas tran vdout0_19ck1500 FIND v(dout0_19) AT=755.025n

.meas tran vdout0_20ck1500 FIND v(dout0_20) AT=755.025n

.meas tran vdout0_21ck1500 FIND v(dout0_21) AT=755.025n

.meas tran vdout0_22ck1500 FIND v(dout0_22) AT=755.025n

.meas tran vdout0_23ck1500 FIND v(dout0_23) AT=755.025n

.meas tran vdout0_24ck1500 FIND v(dout0_24) AT=755.025n

.meas tran vdout0_25ck1500 FIND v(dout0_25) AT=755.025n

.meas tran vdout0_26ck1500 FIND v(dout0_26) AT=755.025n

.meas tran vdout0_27ck1500 FIND v(dout0_27) AT=755.025n

.meas tran vdout0_28ck1500 FIND v(dout0_28) AT=755.025n

.meas tran vdout0_29ck1500 FIND v(dout0_29) AT=755.025n

.meas tran vdout0_30ck1500 FIND v(dout0_30) AT=755.025n

.meas tran vdout0_31ck1500 FIND v(dout0_31) AT=755.025n

.meas tran vdout0_0ck1510 FIND v(dout0_0) AT=760.025n

.meas tran vdout0_1ck1510 FIND v(dout0_1) AT=760.025n

.meas tran vdout0_2ck1510 FIND v(dout0_2) AT=760.025n

.meas tran vdout0_3ck1510 FIND v(dout0_3) AT=760.025n

.meas tran vdout0_4ck1510 FIND v(dout0_4) AT=760.025n

.meas tran vdout0_5ck1510 FIND v(dout0_5) AT=760.025n

.meas tran vdout0_6ck1510 FIND v(dout0_6) AT=760.025n

.meas tran vdout0_7ck1510 FIND v(dout0_7) AT=760.025n

.meas tran vdout0_8ck1510 FIND v(dout0_8) AT=760.025n

.meas tran vdout0_9ck1510 FIND v(dout0_9) AT=760.025n

.meas tran vdout0_10ck1510 FIND v(dout0_10) AT=760.025n

.meas tran vdout0_11ck1510 FIND v(dout0_11) AT=760.025n

.meas tran vdout0_12ck1510 FIND v(dout0_12) AT=760.025n

.meas tran vdout0_13ck1510 FIND v(dout0_13) AT=760.025n

.meas tran vdout0_14ck1510 FIND v(dout0_14) AT=760.025n

.meas tran vdout0_15ck1510 FIND v(dout0_15) AT=760.025n

.meas tran vdout0_16ck1510 FIND v(dout0_16) AT=760.025n

.meas tran vdout0_17ck1510 FIND v(dout0_17) AT=760.025n

.meas tran vdout0_18ck1510 FIND v(dout0_18) AT=760.025n

.meas tran vdout0_19ck1510 FIND v(dout0_19) AT=760.025n

.meas tran vdout0_20ck1510 FIND v(dout0_20) AT=760.025n

.meas tran vdout0_21ck1510 FIND v(dout0_21) AT=760.025n

.meas tran vdout0_22ck1510 FIND v(dout0_22) AT=760.025n

.meas tran vdout0_23ck1510 FIND v(dout0_23) AT=760.025n

.meas tran vdout0_24ck1510 FIND v(dout0_24) AT=760.025n

.meas tran vdout0_25ck1510 FIND v(dout0_25) AT=760.025n

.meas tran vdout0_26ck1510 FIND v(dout0_26) AT=760.025n

.meas tran vdout0_27ck1510 FIND v(dout0_27) AT=760.025n

.meas tran vdout0_28ck1510 FIND v(dout0_28) AT=760.025n

.meas tran vdout0_29ck1510 FIND v(dout0_29) AT=760.025n

.meas tran vdout0_30ck1510 FIND v(dout0_30) AT=760.025n

.meas tran vdout0_31ck1510 FIND v(dout0_31) AT=760.025n

.meas tran vdout0_0ck1520 FIND v(dout0_0) AT=765.025n

.meas tran vdout0_1ck1520 FIND v(dout0_1) AT=765.025n

.meas tran vdout0_2ck1520 FIND v(dout0_2) AT=765.025n

.meas tran vdout0_3ck1520 FIND v(dout0_3) AT=765.025n

.meas tran vdout0_4ck1520 FIND v(dout0_4) AT=765.025n

.meas tran vdout0_5ck1520 FIND v(dout0_5) AT=765.025n

.meas tran vdout0_6ck1520 FIND v(dout0_6) AT=765.025n

.meas tran vdout0_7ck1520 FIND v(dout0_7) AT=765.025n

.meas tran vdout0_8ck1520 FIND v(dout0_8) AT=765.025n

.meas tran vdout0_9ck1520 FIND v(dout0_9) AT=765.025n

.meas tran vdout0_10ck1520 FIND v(dout0_10) AT=765.025n

.meas tran vdout0_11ck1520 FIND v(dout0_11) AT=765.025n

.meas tran vdout0_12ck1520 FIND v(dout0_12) AT=765.025n

.meas tran vdout0_13ck1520 FIND v(dout0_13) AT=765.025n

.meas tran vdout0_14ck1520 FIND v(dout0_14) AT=765.025n

.meas tran vdout0_15ck1520 FIND v(dout0_15) AT=765.025n

.meas tran vdout0_16ck1520 FIND v(dout0_16) AT=765.025n

.meas tran vdout0_17ck1520 FIND v(dout0_17) AT=765.025n

.meas tran vdout0_18ck1520 FIND v(dout0_18) AT=765.025n

.meas tran vdout0_19ck1520 FIND v(dout0_19) AT=765.025n

.meas tran vdout0_20ck1520 FIND v(dout0_20) AT=765.025n

.meas tran vdout0_21ck1520 FIND v(dout0_21) AT=765.025n

.meas tran vdout0_22ck1520 FIND v(dout0_22) AT=765.025n

.meas tran vdout0_23ck1520 FIND v(dout0_23) AT=765.025n

.meas tran vdout0_24ck1520 FIND v(dout0_24) AT=765.025n

.meas tran vdout0_25ck1520 FIND v(dout0_25) AT=765.025n

.meas tran vdout0_26ck1520 FIND v(dout0_26) AT=765.025n

.meas tran vdout0_27ck1520 FIND v(dout0_27) AT=765.025n

.meas tran vdout0_28ck1520 FIND v(dout0_28) AT=765.025n

.meas tran vdout0_29ck1520 FIND v(dout0_29) AT=765.025n

.meas tran vdout0_30ck1520 FIND v(dout0_30) AT=765.025n

.meas tran vdout0_31ck1520 FIND v(dout0_31) AT=765.025n

.meas tran vdout0_0ck1530 FIND v(dout0_0) AT=770.025n

.meas tran vdout0_1ck1530 FIND v(dout0_1) AT=770.025n

.meas tran vdout0_2ck1530 FIND v(dout0_2) AT=770.025n

.meas tran vdout0_3ck1530 FIND v(dout0_3) AT=770.025n

.meas tran vdout0_4ck1530 FIND v(dout0_4) AT=770.025n

.meas tran vdout0_5ck1530 FIND v(dout0_5) AT=770.025n

.meas tran vdout0_6ck1530 FIND v(dout0_6) AT=770.025n

.meas tran vdout0_7ck1530 FIND v(dout0_7) AT=770.025n

.meas tran vdout0_8ck1530 FIND v(dout0_8) AT=770.025n

.meas tran vdout0_9ck1530 FIND v(dout0_9) AT=770.025n

.meas tran vdout0_10ck1530 FIND v(dout0_10) AT=770.025n

.meas tran vdout0_11ck1530 FIND v(dout0_11) AT=770.025n

.meas tran vdout0_12ck1530 FIND v(dout0_12) AT=770.025n

.meas tran vdout0_13ck1530 FIND v(dout0_13) AT=770.025n

.meas tran vdout0_14ck1530 FIND v(dout0_14) AT=770.025n

.meas tran vdout0_15ck1530 FIND v(dout0_15) AT=770.025n

.meas tran vdout0_16ck1530 FIND v(dout0_16) AT=770.025n

.meas tran vdout0_17ck1530 FIND v(dout0_17) AT=770.025n

.meas tran vdout0_18ck1530 FIND v(dout0_18) AT=770.025n

.meas tran vdout0_19ck1530 FIND v(dout0_19) AT=770.025n

.meas tran vdout0_20ck1530 FIND v(dout0_20) AT=770.025n

.meas tran vdout0_21ck1530 FIND v(dout0_21) AT=770.025n

.meas tran vdout0_22ck1530 FIND v(dout0_22) AT=770.025n

.meas tran vdout0_23ck1530 FIND v(dout0_23) AT=770.025n

.meas tran vdout0_24ck1530 FIND v(dout0_24) AT=770.025n

.meas tran vdout0_25ck1530 FIND v(dout0_25) AT=770.025n

.meas tran vdout0_26ck1530 FIND v(dout0_26) AT=770.025n

.meas tran vdout0_27ck1530 FIND v(dout0_27) AT=770.025n

.meas tran vdout0_28ck1530 FIND v(dout0_28) AT=770.025n

.meas tran vdout0_29ck1530 FIND v(dout0_29) AT=770.025n

.meas tran vdout0_30ck1530 FIND v(dout0_30) AT=770.025n

.meas tran vdout0_31ck1530 FIND v(dout0_31) AT=770.025n

.meas tran vdout0_0ck1540 FIND v(dout0_0) AT=775.025n

.meas tran vdout0_1ck1540 FIND v(dout0_1) AT=775.025n

.meas tran vdout0_2ck1540 FIND v(dout0_2) AT=775.025n

.meas tran vdout0_3ck1540 FIND v(dout0_3) AT=775.025n

.meas tran vdout0_4ck1540 FIND v(dout0_4) AT=775.025n

.meas tran vdout0_5ck1540 FIND v(dout0_5) AT=775.025n

.meas tran vdout0_6ck1540 FIND v(dout0_6) AT=775.025n

.meas tran vdout0_7ck1540 FIND v(dout0_7) AT=775.025n

.meas tran vdout0_8ck1540 FIND v(dout0_8) AT=775.025n

.meas tran vdout0_9ck1540 FIND v(dout0_9) AT=775.025n

.meas tran vdout0_10ck1540 FIND v(dout0_10) AT=775.025n

.meas tran vdout0_11ck1540 FIND v(dout0_11) AT=775.025n

.meas tran vdout0_12ck1540 FIND v(dout0_12) AT=775.025n

.meas tran vdout0_13ck1540 FIND v(dout0_13) AT=775.025n

.meas tran vdout0_14ck1540 FIND v(dout0_14) AT=775.025n

.meas tran vdout0_15ck1540 FIND v(dout0_15) AT=775.025n

.meas tran vdout0_16ck1540 FIND v(dout0_16) AT=775.025n

.meas tran vdout0_17ck1540 FIND v(dout0_17) AT=775.025n

.meas tran vdout0_18ck1540 FIND v(dout0_18) AT=775.025n

.meas tran vdout0_19ck1540 FIND v(dout0_19) AT=775.025n

.meas tran vdout0_20ck1540 FIND v(dout0_20) AT=775.025n

.meas tran vdout0_21ck1540 FIND v(dout0_21) AT=775.025n

.meas tran vdout0_22ck1540 FIND v(dout0_22) AT=775.025n

.meas tran vdout0_23ck1540 FIND v(dout0_23) AT=775.025n

.meas tran vdout0_24ck1540 FIND v(dout0_24) AT=775.025n

.meas tran vdout0_25ck1540 FIND v(dout0_25) AT=775.025n

.meas tran vdout0_26ck1540 FIND v(dout0_26) AT=775.025n

.meas tran vdout0_27ck1540 FIND v(dout0_27) AT=775.025n

.meas tran vdout0_28ck1540 FIND v(dout0_28) AT=775.025n

.meas tran vdout0_29ck1540 FIND v(dout0_29) AT=775.025n

.meas tran vdout0_30ck1540 FIND v(dout0_30) AT=775.025n

.meas tran vdout0_31ck1540 FIND v(dout0_31) AT=775.025n

.meas tran vdout0_0ck1560 FIND v(dout0_0) AT=785.025n

.meas tran vdout0_1ck1560 FIND v(dout0_1) AT=785.025n

.meas tran vdout0_2ck1560 FIND v(dout0_2) AT=785.025n

.meas tran vdout0_3ck1560 FIND v(dout0_3) AT=785.025n

.meas tran vdout0_4ck1560 FIND v(dout0_4) AT=785.025n

.meas tran vdout0_5ck1560 FIND v(dout0_5) AT=785.025n

.meas tran vdout0_6ck1560 FIND v(dout0_6) AT=785.025n

.meas tran vdout0_7ck1560 FIND v(dout0_7) AT=785.025n

.meas tran vdout0_8ck1560 FIND v(dout0_8) AT=785.025n

.meas tran vdout0_9ck1560 FIND v(dout0_9) AT=785.025n

.meas tran vdout0_10ck1560 FIND v(dout0_10) AT=785.025n

.meas tran vdout0_11ck1560 FIND v(dout0_11) AT=785.025n

.meas tran vdout0_12ck1560 FIND v(dout0_12) AT=785.025n

.meas tran vdout0_13ck1560 FIND v(dout0_13) AT=785.025n

.meas tran vdout0_14ck1560 FIND v(dout0_14) AT=785.025n

.meas tran vdout0_15ck1560 FIND v(dout0_15) AT=785.025n

.meas tran vdout0_16ck1560 FIND v(dout0_16) AT=785.025n

.meas tran vdout0_17ck1560 FIND v(dout0_17) AT=785.025n

.meas tran vdout0_18ck1560 FIND v(dout0_18) AT=785.025n

.meas tran vdout0_19ck1560 FIND v(dout0_19) AT=785.025n

.meas tran vdout0_20ck1560 FIND v(dout0_20) AT=785.025n

.meas tran vdout0_21ck1560 FIND v(dout0_21) AT=785.025n

.meas tran vdout0_22ck1560 FIND v(dout0_22) AT=785.025n

.meas tran vdout0_23ck1560 FIND v(dout0_23) AT=785.025n

.meas tran vdout0_24ck1560 FIND v(dout0_24) AT=785.025n

.meas tran vdout0_25ck1560 FIND v(dout0_25) AT=785.025n

.meas tran vdout0_26ck1560 FIND v(dout0_26) AT=785.025n

.meas tran vdout0_27ck1560 FIND v(dout0_27) AT=785.025n

.meas tran vdout0_28ck1560 FIND v(dout0_28) AT=785.025n

.meas tran vdout0_29ck1560 FIND v(dout0_29) AT=785.025n

.meas tran vdout0_30ck1560 FIND v(dout0_30) AT=785.025n

.meas tran vdout0_31ck1560 FIND v(dout0_31) AT=785.025n

.meas tran vdout0_0ck1570 FIND v(dout0_0) AT=790.025n

.meas tran vdout0_1ck1570 FIND v(dout0_1) AT=790.025n

.meas tran vdout0_2ck1570 FIND v(dout0_2) AT=790.025n

.meas tran vdout0_3ck1570 FIND v(dout0_3) AT=790.025n

.meas tran vdout0_4ck1570 FIND v(dout0_4) AT=790.025n

.meas tran vdout0_5ck1570 FIND v(dout0_5) AT=790.025n

.meas tran vdout0_6ck1570 FIND v(dout0_6) AT=790.025n

.meas tran vdout0_7ck1570 FIND v(dout0_7) AT=790.025n

.meas tran vdout0_8ck1570 FIND v(dout0_8) AT=790.025n

.meas tran vdout0_9ck1570 FIND v(dout0_9) AT=790.025n

.meas tran vdout0_10ck1570 FIND v(dout0_10) AT=790.025n

.meas tran vdout0_11ck1570 FIND v(dout0_11) AT=790.025n

.meas tran vdout0_12ck1570 FIND v(dout0_12) AT=790.025n

.meas tran vdout0_13ck1570 FIND v(dout0_13) AT=790.025n

.meas tran vdout0_14ck1570 FIND v(dout0_14) AT=790.025n

.meas tran vdout0_15ck1570 FIND v(dout0_15) AT=790.025n

.meas tran vdout0_16ck1570 FIND v(dout0_16) AT=790.025n

.meas tran vdout0_17ck1570 FIND v(dout0_17) AT=790.025n

.meas tran vdout0_18ck1570 FIND v(dout0_18) AT=790.025n

.meas tran vdout0_19ck1570 FIND v(dout0_19) AT=790.025n

.meas tran vdout0_20ck1570 FIND v(dout0_20) AT=790.025n

.meas tran vdout0_21ck1570 FIND v(dout0_21) AT=790.025n

.meas tran vdout0_22ck1570 FIND v(dout0_22) AT=790.025n

.meas tran vdout0_23ck1570 FIND v(dout0_23) AT=790.025n

.meas tran vdout0_24ck1570 FIND v(dout0_24) AT=790.025n

.meas tran vdout0_25ck1570 FIND v(dout0_25) AT=790.025n

.meas tran vdout0_26ck1570 FIND v(dout0_26) AT=790.025n

.meas tran vdout0_27ck1570 FIND v(dout0_27) AT=790.025n

.meas tran vdout0_28ck1570 FIND v(dout0_28) AT=790.025n

.meas tran vdout0_29ck1570 FIND v(dout0_29) AT=790.025n

.meas tran vdout0_30ck1570 FIND v(dout0_30) AT=790.025n

.meas tran vdout0_31ck1570 FIND v(dout0_31) AT=790.025n

.meas tran vdout0_0ck1580 FIND v(dout0_0) AT=795.025n

.meas tran vdout0_1ck1580 FIND v(dout0_1) AT=795.025n

.meas tran vdout0_2ck1580 FIND v(dout0_2) AT=795.025n

.meas tran vdout0_3ck1580 FIND v(dout0_3) AT=795.025n

.meas tran vdout0_4ck1580 FIND v(dout0_4) AT=795.025n

.meas tran vdout0_5ck1580 FIND v(dout0_5) AT=795.025n

.meas tran vdout0_6ck1580 FIND v(dout0_6) AT=795.025n

.meas tran vdout0_7ck1580 FIND v(dout0_7) AT=795.025n

.meas tran vdout0_8ck1580 FIND v(dout0_8) AT=795.025n

.meas tran vdout0_9ck1580 FIND v(dout0_9) AT=795.025n

.meas tran vdout0_10ck1580 FIND v(dout0_10) AT=795.025n

.meas tran vdout0_11ck1580 FIND v(dout0_11) AT=795.025n

.meas tran vdout0_12ck1580 FIND v(dout0_12) AT=795.025n

.meas tran vdout0_13ck1580 FIND v(dout0_13) AT=795.025n

.meas tran vdout0_14ck1580 FIND v(dout0_14) AT=795.025n

.meas tran vdout0_15ck1580 FIND v(dout0_15) AT=795.025n

.meas tran vdout0_16ck1580 FIND v(dout0_16) AT=795.025n

.meas tran vdout0_17ck1580 FIND v(dout0_17) AT=795.025n

.meas tran vdout0_18ck1580 FIND v(dout0_18) AT=795.025n

.meas tran vdout0_19ck1580 FIND v(dout0_19) AT=795.025n

.meas tran vdout0_20ck1580 FIND v(dout0_20) AT=795.025n

.meas tran vdout0_21ck1580 FIND v(dout0_21) AT=795.025n

.meas tran vdout0_22ck1580 FIND v(dout0_22) AT=795.025n

.meas tran vdout0_23ck1580 FIND v(dout0_23) AT=795.025n

.meas tran vdout0_24ck1580 FIND v(dout0_24) AT=795.025n

.meas tran vdout0_25ck1580 FIND v(dout0_25) AT=795.025n

.meas tran vdout0_26ck1580 FIND v(dout0_26) AT=795.025n

.meas tran vdout0_27ck1580 FIND v(dout0_27) AT=795.025n

.meas tran vdout0_28ck1580 FIND v(dout0_28) AT=795.025n

.meas tran vdout0_29ck1580 FIND v(dout0_29) AT=795.025n

.meas tran vdout0_30ck1580 FIND v(dout0_30) AT=795.025n

.meas tran vdout0_31ck1580 FIND v(dout0_31) AT=795.025n

.meas tran vdout0_0ck1620 FIND v(dout0_0) AT=815.025n

.meas tran vdout0_1ck1620 FIND v(dout0_1) AT=815.025n

.meas tran vdout0_2ck1620 FIND v(dout0_2) AT=815.025n

.meas tran vdout0_3ck1620 FIND v(dout0_3) AT=815.025n

.meas tran vdout0_4ck1620 FIND v(dout0_4) AT=815.025n

.meas tran vdout0_5ck1620 FIND v(dout0_5) AT=815.025n

.meas tran vdout0_6ck1620 FIND v(dout0_6) AT=815.025n

.meas tran vdout0_7ck1620 FIND v(dout0_7) AT=815.025n

.meas tran vdout0_8ck1620 FIND v(dout0_8) AT=815.025n

.meas tran vdout0_9ck1620 FIND v(dout0_9) AT=815.025n

.meas tran vdout0_10ck1620 FIND v(dout0_10) AT=815.025n

.meas tran vdout0_11ck1620 FIND v(dout0_11) AT=815.025n

.meas tran vdout0_12ck1620 FIND v(dout0_12) AT=815.025n

.meas tran vdout0_13ck1620 FIND v(dout0_13) AT=815.025n

.meas tran vdout0_14ck1620 FIND v(dout0_14) AT=815.025n

.meas tran vdout0_15ck1620 FIND v(dout0_15) AT=815.025n

.meas tran vdout0_16ck1620 FIND v(dout0_16) AT=815.025n

.meas tran vdout0_17ck1620 FIND v(dout0_17) AT=815.025n

.meas tran vdout0_18ck1620 FIND v(dout0_18) AT=815.025n

.meas tran vdout0_19ck1620 FIND v(dout0_19) AT=815.025n

.meas tran vdout0_20ck1620 FIND v(dout0_20) AT=815.025n

.meas tran vdout0_21ck1620 FIND v(dout0_21) AT=815.025n

.meas tran vdout0_22ck1620 FIND v(dout0_22) AT=815.025n

.meas tran vdout0_23ck1620 FIND v(dout0_23) AT=815.025n

.meas tran vdout0_24ck1620 FIND v(dout0_24) AT=815.025n

.meas tran vdout0_25ck1620 FIND v(dout0_25) AT=815.025n

.meas tran vdout0_26ck1620 FIND v(dout0_26) AT=815.025n

.meas tran vdout0_27ck1620 FIND v(dout0_27) AT=815.025n

.meas tran vdout0_28ck1620 FIND v(dout0_28) AT=815.025n

.meas tran vdout0_29ck1620 FIND v(dout0_29) AT=815.025n

.meas tran vdout0_30ck1620 FIND v(dout0_30) AT=815.025n

.meas tran vdout0_31ck1620 FIND v(dout0_31) AT=815.025n

.meas tran vdout0_0ck1630 FIND v(dout0_0) AT=820.025n

.meas tran vdout0_1ck1630 FIND v(dout0_1) AT=820.025n

.meas tran vdout0_2ck1630 FIND v(dout0_2) AT=820.025n

.meas tran vdout0_3ck1630 FIND v(dout0_3) AT=820.025n

.meas tran vdout0_4ck1630 FIND v(dout0_4) AT=820.025n

.meas tran vdout0_5ck1630 FIND v(dout0_5) AT=820.025n

.meas tran vdout0_6ck1630 FIND v(dout0_6) AT=820.025n

.meas tran vdout0_7ck1630 FIND v(dout0_7) AT=820.025n

.meas tran vdout0_8ck1630 FIND v(dout0_8) AT=820.025n

.meas tran vdout0_9ck1630 FIND v(dout0_9) AT=820.025n

.meas tran vdout0_10ck1630 FIND v(dout0_10) AT=820.025n

.meas tran vdout0_11ck1630 FIND v(dout0_11) AT=820.025n

.meas tran vdout0_12ck1630 FIND v(dout0_12) AT=820.025n

.meas tran vdout0_13ck1630 FIND v(dout0_13) AT=820.025n

.meas tran vdout0_14ck1630 FIND v(dout0_14) AT=820.025n

.meas tran vdout0_15ck1630 FIND v(dout0_15) AT=820.025n

.meas tran vdout0_16ck1630 FIND v(dout0_16) AT=820.025n

.meas tran vdout0_17ck1630 FIND v(dout0_17) AT=820.025n

.meas tran vdout0_18ck1630 FIND v(dout0_18) AT=820.025n

.meas tran vdout0_19ck1630 FIND v(dout0_19) AT=820.025n

.meas tran vdout0_20ck1630 FIND v(dout0_20) AT=820.025n

.meas tran vdout0_21ck1630 FIND v(dout0_21) AT=820.025n

.meas tran vdout0_22ck1630 FIND v(dout0_22) AT=820.025n

.meas tran vdout0_23ck1630 FIND v(dout0_23) AT=820.025n

.meas tran vdout0_24ck1630 FIND v(dout0_24) AT=820.025n

.meas tran vdout0_25ck1630 FIND v(dout0_25) AT=820.025n

.meas tran vdout0_26ck1630 FIND v(dout0_26) AT=820.025n

.meas tran vdout0_27ck1630 FIND v(dout0_27) AT=820.025n

.meas tran vdout0_28ck1630 FIND v(dout0_28) AT=820.025n

.meas tran vdout0_29ck1630 FIND v(dout0_29) AT=820.025n

.meas tran vdout0_30ck1630 FIND v(dout0_30) AT=820.025n

.meas tran vdout0_31ck1630 FIND v(dout0_31) AT=820.025n

.meas tran vdout0_0ck1640 FIND v(dout0_0) AT=825.025n

.meas tran vdout0_1ck1640 FIND v(dout0_1) AT=825.025n

.meas tran vdout0_2ck1640 FIND v(dout0_2) AT=825.025n

.meas tran vdout0_3ck1640 FIND v(dout0_3) AT=825.025n

.meas tran vdout0_4ck1640 FIND v(dout0_4) AT=825.025n

.meas tran vdout0_5ck1640 FIND v(dout0_5) AT=825.025n

.meas tran vdout0_6ck1640 FIND v(dout0_6) AT=825.025n

.meas tran vdout0_7ck1640 FIND v(dout0_7) AT=825.025n

.meas tran vdout0_8ck1640 FIND v(dout0_8) AT=825.025n

.meas tran vdout0_9ck1640 FIND v(dout0_9) AT=825.025n

.meas tran vdout0_10ck1640 FIND v(dout0_10) AT=825.025n

.meas tran vdout0_11ck1640 FIND v(dout0_11) AT=825.025n

.meas tran vdout0_12ck1640 FIND v(dout0_12) AT=825.025n

.meas tran vdout0_13ck1640 FIND v(dout0_13) AT=825.025n

.meas tran vdout0_14ck1640 FIND v(dout0_14) AT=825.025n

.meas tran vdout0_15ck1640 FIND v(dout0_15) AT=825.025n

.meas tran vdout0_16ck1640 FIND v(dout0_16) AT=825.025n

.meas tran vdout0_17ck1640 FIND v(dout0_17) AT=825.025n

.meas tran vdout0_18ck1640 FIND v(dout0_18) AT=825.025n

.meas tran vdout0_19ck1640 FIND v(dout0_19) AT=825.025n

.meas tran vdout0_20ck1640 FIND v(dout0_20) AT=825.025n

.meas tran vdout0_21ck1640 FIND v(dout0_21) AT=825.025n

.meas tran vdout0_22ck1640 FIND v(dout0_22) AT=825.025n

.meas tran vdout0_23ck1640 FIND v(dout0_23) AT=825.025n

.meas tran vdout0_24ck1640 FIND v(dout0_24) AT=825.025n

.meas tran vdout0_25ck1640 FIND v(dout0_25) AT=825.025n

.meas tran vdout0_26ck1640 FIND v(dout0_26) AT=825.025n

.meas tran vdout0_27ck1640 FIND v(dout0_27) AT=825.025n

.meas tran vdout0_28ck1640 FIND v(dout0_28) AT=825.025n

.meas tran vdout0_29ck1640 FIND v(dout0_29) AT=825.025n

.meas tran vdout0_30ck1640 FIND v(dout0_30) AT=825.025n

.meas tran vdout0_31ck1640 FIND v(dout0_31) AT=825.025n

.meas tran vdout0_0ck1660 FIND v(dout0_0) AT=835.025n

.meas tran vdout0_1ck1660 FIND v(dout0_1) AT=835.025n

.meas tran vdout0_2ck1660 FIND v(dout0_2) AT=835.025n

.meas tran vdout0_3ck1660 FIND v(dout0_3) AT=835.025n

.meas tran vdout0_4ck1660 FIND v(dout0_4) AT=835.025n

.meas tran vdout0_5ck1660 FIND v(dout0_5) AT=835.025n

.meas tran vdout0_6ck1660 FIND v(dout0_6) AT=835.025n

.meas tran vdout0_7ck1660 FIND v(dout0_7) AT=835.025n

.meas tran vdout0_8ck1660 FIND v(dout0_8) AT=835.025n

.meas tran vdout0_9ck1660 FIND v(dout0_9) AT=835.025n

.meas tran vdout0_10ck1660 FIND v(dout0_10) AT=835.025n

.meas tran vdout0_11ck1660 FIND v(dout0_11) AT=835.025n

.meas tran vdout0_12ck1660 FIND v(dout0_12) AT=835.025n

.meas tran vdout0_13ck1660 FIND v(dout0_13) AT=835.025n

.meas tran vdout0_14ck1660 FIND v(dout0_14) AT=835.025n

.meas tran vdout0_15ck1660 FIND v(dout0_15) AT=835.025n

.meas tran vdout0_16ck1660 FIND v(dout0_16) AT=835.025n

.meas tran vdout0_17ck1660 FIND v(dout0_17) AT=835.025n

.meas tran vdout0_18ck1660 FIND v(dout0_18) AT=835.025n

.meas tran vdout0_19ck1660 FIND v(dout0_19) AT=835.025n

.meas tran vdout0_20ck1660 FIND v(dout0_20) AT=835.025n

.meas tran vdout0_21ck1660 FIND v(dout0_21) AT=835.025n

.meas tran vdout0_22ck1660 FIND v(dout0_22) AT=835.025n

.meas tran vdout0_23ck1660 FIND v(dout0_23) AT=835.025n

.meas tran vdout0_24ck1660 FIND v(dout0_24) AT=835.025n

.meas tran vdout0_25ck1660 FIND v(dout0_25) AT=835.025n

.meas tran vdout0_26ck1660 FIND v(dout0_26) AT=835.025n

.meas tran vdout0_27ck1660 FIND v(dout0_27) AT=835.025n

.meas tran vdout0_28ck1660 FIND v(dout0_28) AT=835.025n

.meas tran vdout0_29ck1660 FIND v(dout0_29) AT=835.025n

.meas tran vdout0_30ck1660 FIND v(dout0_30) AT=835.025n

.meas tran vdout0_31ck1660 FIND v(dout0_31) AT=835.025n

.meas tran vdout0_0ck1670 FIND v(dout0_0) AT=840.025n

.meas tran vdout0_1ck1670 FIND v(dout0_1) AT=840.025n

.meas tran vdout0_2ck1670 FIND v(dout0_2) AT=840.025n

.meas tran vdout0_3ck1670 FIND v(dout0_3) AT=840.025n

.meas tran vdout0_4ck1670 FIND v(dout0_4) AT=840.025n

.meas tran vdout0_5ck1670 FIND v(dout0_5) AT=840.025n

.meas tran vdout0_6ck1670 FIND v(dout0_6) AT=840.025n

.meas tran vdout0_7ck1670 FIND v(dout0_7) AT=840.025n

.meas tran vdout0_8ck1670 FIND v(dout0_8) AT=840.025n

.meas tran vdout0_9ck1670 FIND v(dout0_9) AT=840.025n

.meas tran vdout0_10ck1670 FIND v(dout0_10) AT=840.025n

.meas tran vdout0_11ck1670 FIND v(dout0_11) AT=840.025n

.meas tran vdout0_12ck1670 FIND v(dout0_12) AT=840.025n

.meas tran vdout0_13ck1670 FIND v(dout0_13) AT=840.025n

.meas tran vdout0_14ck1670 FIND v(dout0_14) AT=840.025n

.meas tran vdout0_15ck1670 FIND v(dout0_15) AT=840.025n

.meas tran vdout0_16ck1670 FIND v(dout0_16) AT=840.025n

.meas tran vdout0_17ck1670 FIND v(dout0_17) AT=840.025n

.meas tran vdout0_18ck1670 FIND v(dout0_18) AT=840.025n

.meas tran vdout0_19ck1670 FIND v(dout0_19) AT=840.025n

.meas tran vdout0_20ck1670 FIND v(dout0_20) AT=840.025n

.meas tran vdout0_21ck1670 FIND v(dout0_21) AT=840.025n

.meas tran vdout0_22ck1670 FIND v(dout0_22) AT=840.025n

.meas tran vdout0_23ck1670 FIND v(dout0_23) AT=840.025n

.meas tran vdout0_24ck1670 FIND v(dout0_24) AT=840.025n

.meas tran vdout0_25ck1670 FIND v(dout0_25) AT=840.025n

.meas tran vdout0_26ck1670 FIND v(dout0_26) AT=840.025n

.meas tran vdout0_27ck1670 FIND v(dout0_27) AT=840.025n

.meas tran vdout0_28ck1670 FIND v(dout0_28) AT=840.025n

.meas tran vdout0_29ck1670 FIND v(dout0_29) AT=840.025n

.meas tran vdout0_30ck1670 FIND v(dout0_30) AT=840.025n

.meas tran vdout0_31ck1670 FIND v(dout0_31) AT=840.025n

.meas tran vdout0_0ck1710 FIND v(dout0_0) AT=860.025n

.meas tran vdout0_1ck1710 FIND v(dout0_1) AT=860.025n

.meas tran vdout0_2ck1710 FIND v(dout0_2) AT=860.025n

.meas tran vdout0_3ck1710 FIND v(dout0_3) AT=860.025n

.meas tran vdout0_4ck1710 FIND v(dout0_4) AT=860.025n

.meas tran vdout0_5ck1710 FIND v(dout0_5) AT=860.025n

.meas tran vdout0_6ck1710 FIND v(dout0_6) AT=860.025n

.meas tran vdout0_7ck1710 FIND v(dout0_7) AT=860.025n

.meas tran vdout0_8ck1710 FIND v(dout0_8) AT=860.025n

.meas tran vdout0_9ck1710 FIND v(dout0_9) AT=860.025n

.meas tran vdout0_10ck1710 FIND v(dout0_10) AT=860.025n

.meas tran vdout0_11ck1710 FIND v(dout0_11) AT=860.025n

.meas tran vdout0_12ck1710 FIND v(dout0_12) AT=860.025n

.meas tran vdout0_13ck1710 FIND v(dout0_13) AT=860.025n

.meas tran vdout0_14ck1710 FIND v(dout0_14) AT=860.025n

.meas tran vdout0_15ck1710 FIND v(dout0_15) AT=860.025n

.meas tran vdout0_16ck1710 FIND v(dout0_16) AT=860.025n

.meas tran vdout0_17ck1710 FIND v(dout0_17) AT=860.025n

.meas tran vdout0_18ck1710 FIND v(dout0_18) AT=860.025n

.meas tran vdout0_19ck1710 FIND v(dout0_19) AT=860.025n

.meas tran vdout0_20ck1710 FIND v(dout0_20) AT=860.025n

.meas tran vdout0_21ck1710 FIND v(dout0_21) AT=860.025n

.meas tran vdout0_22ck1710 FIND v(dout0_22) AT=860.025n

.meas tran vdout0_23ck1710 FIND v(dout0_23) AT=860.025n

.meas tran vdout0_24ck1710 FIND v(dout0_24) AT=860.025n

.meas tran vdout0_25ck1710 FIND v(dout0_25) AT=860.025n

.meas tran vdout0_26ck1710 FIND v(dout0_26) AT=860.025n

.meas tran vdout0_27ck1710 FIND v(dout0_27) AT=860.025n

.meas tran vdout0_28ck1710 FIND v(dout0_28) AT=860.025n

.meas tran vdout0_29ck1710 FIND v(dout0_29) AT=860.025n

.meas tran vdout0_30ck1710 FIND v(dout0_30) AT=860.025n

.meas tran vdout0_31ck1710 FIND v(dout0_31) AT=860.025n

.meas tran vdout0_0ck1720 FIND v(dout0_0) AT=865.025n

.meas tran vdout0_1ck1720 FIND v(dout0_1) AT=865.025n

.meas tran vdout0_2ck1720 FIND v(dout0_2) AT=865.025n

.meas tran vdout0_3ck1720 FIND v(dout0_3) AT=865.025n

.meas tran vdout0_4ck1720 FIND v(dout0_4) AT=865.025n

.meas tran vdout0_5ck1720 FIND v(dout0_5) AT=865.025n

.meas tran vdout0_6ck1720 FIND v(dout0_6) AT=865.025n

.meas tran vdout0_7ck1720 FIND v(dout0_7) AT=865.025n

.meas tran vdout0_8ck1720 FIND v(dout0_8) AT=865.025n

.meas tran vdout0_9ck1720 FIND v(dout0_9) AT=865.025n

.meas tran vdout0_10ck1720 FIND v(dout0_10) AT=865.025n

.meas tran vdout0_11ck1720 FIND v(dout0_11) AT=865.025n

.meas tran vdout0_12ck1720 FIND v(dout0_12) AT=865.025n

.meas tran vdout0_13ck1720 FIND v(dout0_13) AT=865.025n

.meas tran vdout0_14ck1720 FIND v(dout0_14) AT=865.025n

.meas tran vdout0_15ck1720 FIND v(dout0_15) AT=865.025n

.meas tran vdout0_16ck1720 FIND v(dout0_16) AT=865.025n

.meas tran vdout0_17ck1720 FIND v(dout0_17) AT=865.025n

.meas tran vdout0_18ck1720 FIND v(dout0_18) AT=865.025n

.meas tran vdout0_19ck1720 FIND v(dout0_19) AT=865.025n

.meas tran vdout0_20ck1720 FIND v(dout0_20) AT=865.025n

.meas tran vdout0_21ck1720 FIND v(dout0_21) AT=865.025n

.meas tran vdout0_22ck1720 FIND v(dout0_22) AT=865.025n

.meas tran vdout0_23ck1720 FIND v(dout0_23) AT=865.025n

.meas tran vdout0_24ck1720 FIND v(dout0_24) AT=865.025n

.meas tran vdout0_25ck1720 FIND v(dout0_25) AT=865.025n

.meas tran vdout0_26ck1720 FIND v(dout0_26) AT=865.025n

.meas tran vdout0_27ck1720 FIND v(dout0_27) AT=865.025n

.meas tran vdout0_28ck1720 FIND v(dout0_28) AT=865.025n

.meas tran vdout0_29ck1720 FIND v(dout0_29) AT=865.025n

.meas tran vdout0_30ck1720 FIND v(dout0_30) AT=865.025n

.meas tran vdout0_31ck1720 FIND v(dout0_31) AT=865.025n

.meas tran vdout0_0ck1730 FIND v(dout0_0) AT=870.025n

.meas tran vdout0_1ck1730 FIND v(dout0_1) AT=870.025n

.meas tran vdout0_2ck1730 FIND v(dout0_2) AT=870.025n

.meas tran vdout0_3ck1730 FIND v(dout0_3) AT=870.025n

.meas tran vdout0_4ck1730 FIND v(dout0_4) AT=870.025n

.meas tran vdout0_5ck1730 FIND v(dout0_5) AT=870.025n

.meas tran vdout0_6ck1730 FIND v(dout0_6) AT=870.025n

.meas tran vdout0_7ck1730 FIND v(dout0_7) AT=870.025n

.meas tran vdout0_8ck1730 FIND v(dout0_8) AT=870.025n

.meas tran vdout0_9ck1730 FIND v(dout0_9) AT=870.025n

.meas tran vdout0_10ck1730 FIND v(dout0_10) AT=870.025n

.meas tran vdout0_11ck1730 FIND v(dout0_11) AT=870.025n

.meas tran vdout0_12ck1730 FIND v(dout0_12) AT=870.025n

.meas tran vdout0_13ck1730 FIND v(dout0_13) AT=870.025n

.meas tran vdout0_14ck1730 FIND v(dout0_14) AT=870.025n

.meas tran vdout0_15ck1730 FIND v(dout0_15) AT=870.025n

.meas tran vdout0_16ck1730 FIND v(dout0_16) AT=870.025n

.meas tran vdout0_17ck1730 FIND v(dout0_17) AT=870.025n

.meas tran vdout0_18ck1730 FIND v(dout0_18) AT=870.025n

.meas tran vdout0_19ck1730 FIND v(dout0_19) AT=870.025n

.meas tran vdout0_20ck1730 FIND v(dout0_20) AT=870.025n

.meas tran vdout0_21ck1730 FIND v(dout0_21) AT=870.025n

.meas tran vdout0_22ck1730 FIND v(dout0_22) AT=870.025n

.meas tran vdout0_23ck1730 FIND v(dout0_23) AT=870.025n

.meas tran vdout0_24ck1730 FIND v(dout0_24) AT=870.025n

.meas tran vdout0_25ck1730 FIND v(dout0_25) AT=870.025n

.meas tran vdout0_26ck1730 FIND v(dout0_26) AT=870.025n

.meas tran vdout0_27ck1730 FIND v(dout0_27) AT=870.025n

.meas tran vdout0_28ck1730 FIND v(dout0_28) AT=870.025n

.meas tran vdout0_29ck1730 FIND v(dout0_29) AT=870.025n

.meas tran vdout0_30ck1730 FIND v(dout0_30) AT=870.025n

.meas tran vdout0_31ck1730 FIND v(dout0_31) AT=870.025n

.meas tran vdout0_0ck1750 FIND v(dout0_0) AT=880.025n

.meas tran vdout0_1ck1750 FIND v(dout0_1) AT=880.025n

.meas tran vdout0_2ck1750 FIND v(dout0_2) AT=880.025n

.meas tran vdout0_3ck1750 FIND v(dout0_3) AT=880.025n

.meas tran vdout0_4ck1750 FIND v(dout0_4) AT=880.025n

.meas tran vdout0_5ck1750 FIND v(dout0_5) AT=880.025n

.meas tran vdout0_6ck1750 FIND v(dout0_6) AT=880.025n

.meas tran vdout0_7ck1750 FIND v(dout0_7) AT=880.025n

.meas tran vdout0_8ck1750 FIND v(dout0_8) AT=880.025n

.meas tran vdout0_9ck1750 FIND v(dout0_9) AT=880.025n

.meas tran vdout0_10ck1750 FIND v(dout0_10) AT=880.025n

.meas tran vdout0_11ck1750 FIND v(dout0_11) AT=880.025n

.meas tran vdout0_12ck1750 FIND v(dout0_12) AT=880.025n

.meas tran vdout0_13ck1750 FIND v(dout0_13) AT=880.025n

.meas tran vdout0_14ck1750 FIND v(dout0_14) AT=880.025n

.meas tran vdout0_15ck1750 FIND v(dout0_15) AT=880.025n

.meas tran vdout0_16ck1750 FIND v(dout0_16) AT=880.025n

.meas tran vdout0_17ck1750 FIND v(dout0_17) AT=880.025n

.meas tran vdout0_18ck1750 FIND v(dout0_18) AT=880.025n

.meas tran vdout0_19ck1750 FIND v(dout0_19) AT=880.025n

.meas tran vdout0_20ck1750 FIND v(dout0_20) AT=880.025n

.meas tran vdout0_21ck1750 FIND v(dout0_21) AT=880.025n

.meas tran vdout0_22ck1750 FIND v(dout0_22) AT=880.025n

.meas tran vdout0_23ck1750 FIND v(dout0_23) AT=880.025n

.meas tran vdout0_24ck1750 FIND v(dout0_24) AT=880.025n

.meas tran vdout0_25ck1750 FIND v(dout0_25) AT=880.025n

.meas tran vdout0_26ck1750 FIND v(dout0_26) AT=880.025n

.meas tran vdout0_27ck1750 FIND v(dout0_27) AT=880.025n

.meas tran vdout0_28ck1750 FIND v(dout0_28) AT=880.025n

.meas tran vdout0_29ck1750 FIND v(dout0_29) AT=880.025n

.meas tran vdout0_30ck1750 FIND v(dout0_30) AT=880.025n

.meas tran vdout0_31ck1750 FIND v(dout0_31) AT=880.025n

.meas tran vdout0_0ck1760 FIND v(dout0_0) AT=885.025n

.meas tran vdout0_1ck1760 FIND v(dout0_1) AT=885.025n

.meas tran vdout0_2ck1760 FIND v(dout0_2) AT=885.025n

.meas tran vdout0_3ck1760 FIND v(dout0_3) AT=885.025n

.meas tran vdout0_4ck1760 FIND v(dout0_4) AT=885.025n

.meas tran vdout0_5ck1760 FIND v(dout0_5) AT=885.025n

.meas tran vdout0_6ck1760 FIND v(dout0_6) AT=885.025n

.meas tran vdout0_7ck1760 FIND v(dout0_7) AT=885.025n

.meas tran vdout0_8ck1760 FIND v(dout0_8) AT=885.025n

.meas tran vdout0_9ck1760 FIND v(dout0_9) AT=885.025n

.meas tran vdout0_10ck1760 FIND v(dout0_10) AT=885.025n

.meas tran vdout0_11ck1760 FIND v(dout0_11) AT=885.025n

.meas tran vdout0_12ck1760 FIND v(dout0_12) AT=885.025n

.meas tran vdout0_13ck1760 FIND v(dout0_13) AT=885.025n

.meas tran vdout0_14ck1760 FIND v(dout0_14) AT=885.025n

.meas tran vdout0_15ck1760 FIND v(dout0_15) AT=885.025n

.meas tran vdout0_16ck1760 FIND v(dout0_16) AT=885.025n

.meas tran vdout0_17ck1760 FIND v(dout0_17) AT=885.025n

.meas tran vdout0_18ck1760 FIND v(dout0_18) AT=885.025n

.meas tran vdout0_19ck1760 FIND v(dout0_19) AT=885.025n

.meas tran vdout0_20ck1760 FIND v(dout0_20) AT=885.025n

.meas tran vdout0_21ck1760 FIND v(dout0_21) AT=885.025n

.meas tran vdout0_22ck1760 FIND v(dout0_22) AT=885.025n

.meas tran vdout0_23ck1760 FIND v(dout0_23) AT=885.025n

.meas tran vdout0_24ck1760 FIND v(dout0_24) AT=885.025n

.meas tran vdout0_25ck1760 FIND v(dout0_25) AT=885.025n

.meas tran vdout0_26ck1760 FIND v(dout0_26) AT=885.025n

.meas tran vdout0_27ck1760 FIND v(dout0_27) AT=885.025n

.meas tran vdout0_28ck1760 FIND v(dout0_28) AT=885.025n

.meas tran vdout0_29ck1760 FIND v(dout0_29) AT=885.025n

.meas tran vdout0_30ck1760 FIND v(dout0_30) AT=885.025n

.meas tran vdout0_31ck1760 FIND v(dout0_31) AT=885.025n

.meas tran vdout0_0ck1800 FIND v(dout0_0) AT=905.025n

.meas tran vdout0_1ck1800 FIND v(dout0_1) AT=905.025n

.meas tran vdout0_2ck1800 FIND v(dout0_2) AT=905.025n

.meas tran vdout0_3ck1800 FIND v(dout0_3) AT=905.025n

.meas tran vdout0_4ck1800 FIND v(dout0_4) AT=905.025n

.meas tran vdout0_5ck1800 FIND v(dout0_5) AT=905.025n

.meas tran vdout0_6ck1800 FIND v(dout0_6) AT=905.025n

.meas tran vdout0_7ck1800 FIND v(dout0_7) AT=905.025n

.meas tran vdout0_8ck1800 FIND v(dout0_8) AT=905.025n

.meas tran vdout0_9ck1800 FIND v(dout0_9) AT=905.025n

.meas tran vdout0_10ck1800 FIND v(dout0_10) AT=905.025n

.meas tran vdout0_11ck1800 FIND v(dout0_11) AT=905.025n

.meas tran vdout0_12ck1800 FIND v(dout0_12) AT=905.025n

.meas tran vdout0_13ck1800 FIND v(dout0_13) AT=905.025n

.meas tran vdout0_14ck1800 FIND v(dout0_14) AT=905.025n

.meas tran vdout0_15ck1800 FIND v(dout0_15) AT=905.025n

.meas tran vdout0_16ck1800 FIND v(dout0_16) AT=905.025n

.meas tran vdout0_17ck1800 FIND v(dout0_17) AT=905.025n

.meas tran vdout0_18ck1800 FIND v(dout0_18) AT=905.025n

.meas tran vdout0_19ck1800 FIND v(dout0_19) AT=905.025n

.meas tran vdout0_20ck1800 FIND v(dout0_20) AT=905.025n

.meas tran vdout0_21ck1800 FIND v(dout0_21) AT=905.025n

.meas tran vdout0_22ck1800 FIND v(dout0_22) AT=905.025n

.meas tran vdout0_23ck1800 FIND v(dout0_23) AT=905.025n

.meas tran vdout0_24ck1800 FIND v(dout0_24) AT=905.025n

.meas tran vdout0_25ck1800 FIND v(dout0_25) AT=905.025n

.meas tran vdout0_26ck1800 FIND v(dout0_26) AT=905.025n

.meas tran vdout0_27ck1800 FIND v(dout0_27) AT=905.025n

.meas tran vdout0_28ck1800 FIND v(dout0_28) AT=905.025n

.meas tran vdout0_29ck1800 FIND v(dout0_29) AT=905.025n

.meas tran vdout0_30ck1800 FIND v(dout0_30) AT=905.025n

.meas tran vdout0_31ck1800 FIND v(dout0_31) AT=905.025n

.meas tran vdout0_0ck1810 FIND v(dout0_0) AT=910.025n

.meas tran vdout0_1ck1810 FIND v(dout0_1) AT=910.025n

.meas tran vdout0_2ck1810 FIND v(dout0_2) AT=910.025n

.meas tran vdout0_3ck1810 FIND v(dout0_3) AT=910.025n

.meas tran vdout0_4ck1810 FIND v(dout0_4) AT=910.025n

.meas tran vdout0_5ck1810 FIND v(dout0_5) AT=910.025n

.meas tran vdout0_6ck1810 FIND v(dout0_6) AT=910.025n

.meas tran vdout0_7ck1810 FIND v(dout0_7) AT=910.025n

.meas tran vdout0_8ck1810 FIND v(dout0_8) AT=910.025n

.meas tran vdout0_9ck1810 FIND v(dout0_9) AT=910.025n

.meas tran vdout0_10ck1810 FIND v(dout0_10) AT=910.025n

.meas tran vdout0_11ck1810 FIND v(dout0_11) AT=910.025n

.meas tran vdout0_12ck1810 FIND v(dout0_12) AT=910.025n

.meas tran vdout0_13ck1810 FIND v(dout0_13) AT=910.025n

.meas tran vdout0_14ck1810 FIND v(dout0_14) AT=910.025n

.meas tran vdout0_15ck1810 FIND v(dout0_15) AT=910.025n

.meas tran vdout0_16ck1810 FIND v(dout0_16) AT=910.025n

.meas tran vdout0_17ck1810 FIND v(dout0_17) AT=910.025n

.meas tran vdout0_18ck1810 FIND v(dout0_18) AT=910.025n

.meas tran vdout0_19ck1810 FIND v(dout0_19) AT=910.025n

.meas tran vdout0_20ck1810 FIND v(dout0_20) AT=910.025n

.meas tran vdout0_21ck1810 FIND v(dout0_21) AT=910.025n

.meas tran vdout0_22ck1810 FIND v(dout0_22) AT=910.025n

.meas tran vdout0_23ck1810 FIND v(dout0_23) AT=910.025n

.meas tran vdout0_24ck1810 FIND v(dout0_24) AT=910.025n

.meas tran vdout0_25ck1810 FIND v(dout0_25) AT=910.025n

.meas tran vdout0_26ck1810 FIND v(dout0_26) AT=910.025n

.meas tran vdout0_27ck1810 FIND v(dout0_27) AT=910.025n

.meas tran vdout0_28ck1810 FIND v(dout0_28) AT=910.025n

.meas tran vdout0_29ck1810 FIND v(dout0_29) AT=910.025n

.meas tran vdout0_30ck1810 FIND v(dout0_30) AT=910.025n

.meas tran vdout0_31ck1810 FIND v(dout0_31) AT=910.025n

.meas tran vdout0_0ck1820 FIND v(dout0_0) AT=915.025n

.meas tran vdout0_1ck1820 FIND v(dout0_1) AT=915.025n

.meas tran vdout0_2ck1820 FIND v(dout0_2) AT=915.025n

.meas tran vdout0_3ck1820 FIND v(dout0_3) AT=915.025n

.meas tran vdout0_4ck1820 FIND v(dout0_4) AT=915.025n

.meas tran vdout0_5ck1820 FIND v(dout0_5) AT=915.025n

.meas tran vdout0_6ck1820 FIND v(dout0_6) AT=915.025n

.meas tran vdout0_7ck1820 FIND v(dout0_7) AT=915.025n

.meas tran vdout0_8ck1820 FIND v(dout0_8) AT=915.025n

.meas tran vdout0_9ck1820 FIND v(dout0_9) AT=915.025n

.meas tran vdout0_10ck1820 FIND v(dout0_10) AT=915.025n

.meas tran vdout0_11ck1820 FIND v(dout0_11) AT=915.025n

.meas tran vdout0_12ck1820 FIND v(dout0_12) AT=915.025n

.meas tran vdout0_13ck1820 FIND v(dout0_13) AT=915.025n

.meas tran vdout0_14ck1820 FIND v(dout0_14) AT=915.025n

.meas tran vdout0_15ck1820 FIND v(dout0_15) AT=915.025n

.meas tran vdout0_16ck1820 FIND v(dout0_16) AT=915.025n

.meas tran vdout0_17ck1820 FIND v(dout0_17) AT=915.025n

.meas tran vdout0_18ck1820 FIND v(dout0_18) AT=915.025n

.meas tran vdout0_19ck1820 FIND v(dout0_19) AT=915.025n

.meas tran vdout0_20ck1820 FIND v(dout0_20) AT=915.025n

.meas tran vdout0_21ck1820 FIND v(dout0_21) AT=915.025n

.meas tran vdout0_22ck1820 FIND v(dout0_22) AT=915.025n

.meas tran vdout0_23ck1820 FIND v(dout0_23) AT=915.025n

.meas tran vdout0_24ck1820 FIND v(dout0_24) AT=915.025n

.meas tran vdout0_25ck1820 FIND v(dout0_25) AT=915.025n

.meas tran vdout0_26ck1820 FIND v(dout0_26) AT=915.025n

.meas tran vdout0_27ck1820 FIND v(dout0_27) AT=915.025n

.meas tran vdout0_28ck1820 FIND v(dout0_28) AT=915.025n

.meas tran vdout0_29ck1820 FIND v(dout0_29) AT=915.025n

.meas tran vdout0_30ck1820 FIND v(dout0_30) AT=915.025n

.meas tran vdout0_31ck1820 FIND v(dout0_31) AT=915.025n

.meas tran vdout0_0ck1830 FIND v(dout0_0) AT=920.025n

.meas tran vdout0_1ck1830 FIND v(dout0_1) AT=920.025n

.meas tran vdout0_2ck1830 FIND v(dout0_2) AT=920.025n

.meas tran vdout0_3ck1830 FIND v(dout0_3) AT=920.025n

.meas tran vdout0_4ck1830 FIND v(dout0_4) AT=920.025n

.meas tran vdout0_5ck1830 FIND v(dout0_5) AT=920.025n

.meas tran vdout0_6ck1830 FIND v(dout0_6) AT=920.025n

.meas tran vdout0_7ck1830 FIND v(dout0_7) AT=920.025n

.meas tran vdout0_8ck1830 FIND v(dout0_8) AT=920.025n

.meas tran vdout0_9ck1830 FIND v(dout0_9) AT=920.025n

.meas tran vdout0_10ck1830 FIND v(dout0_10) AT=920.025n

.meas tran vdout0_11ck1830 FIND v(dout0_11) AT=920.025n

.meas tran vdout0_12ck1830 FIND v(dout0_12) AT=920.025n

.meas tran vdout0_13ck1830 FIND v(dout0_13) AT=920.025n

.meas tran vdout0_14ck1830 FIND v(dout0_14) AT=920.025n

.meas tran vdout0_15ck1830 FIND v(dout0_15) AT=920.025n

.meas tran vdout0_16ck1830 FIND v(dout0_16) AT=920.025n

.meas tran vdout0_17ck1830 FIND v(dout0_17) AT=920.025n

.meas tran vdout0_18ck1830 FIND v(dout0_18) AT=920.025n

.meas tran vdout0_19ck1830 FIND v(dout0_19) AT=920.025n

.meas tran vdout0_20ck1830 FIND v(dout0_20) AT=920.025n

.meas tran vdout0_21ck1830 FIND v(dout0_21) AT=920.025n

.meas tran vdout0_22ck1830 FIND v(dout0_22) AT=920.025n

.meas tran vdout0_23ck1830 FIND v(dout0_23) AT=920.025n

.meas tran vdout0_24ck1830 FIND v(dout0_24) AT=920.025n

.meas tran vdout0_25ck1830 FIND v(dout0_25) AT=920.025n

.meas tran vdout0_26ck1830 FIND v(dout0_26) AT=920.025n

.meas tran vdout0_27ck1830 FIND v(dout0_27) AT=920.025n

.meas tran vdout0_28ck1830 FIND v(dout0_28) AT=920.025n

.meas tran vdout0_29ck1830 FIND v(dout0_29) AT=920.025n

.meas tran vdout0_30ck1830 FIND v(dout0_30) AT=920.025n

.meas tran vdout0_31ck1830 FIND v(dout0_31) AT=920.025n

.meas tran vdout0_0ck1850 FIND v(dout0_0) AT=930.025n

.meas tran vdout0_1ck1850 FIND v(dout0_1) AT=930.025n

.meas tran vdout0_2ck1850 FIND v(dout0_2) AT=930.025n

.meas tran vdout0_3ck1850 FIND v(dout0_3) AT=930.025n

.meas tran vdout0_4ck1850 FIND v(dout0_4) AT=930.025n

.meas tran vdout0_5ck1850 FIND v(dout0_5) AT=930.025n

.meas tran vdout0_6ck1850 FIND v(dout0_6) AT=930.025n

.meas tran vdout0_7ck1850 FIND v(dout0_7) AT=930.025n

.meas tran vdout0_8ck1850 FIND v(dout0_8) AT=930.025n

.meas tran vdout0_9ck1850 FIND v(dout0_9) AT=930.025n

.meas tran vdout0_10ck1850 FIND v(dout0_10) AT=930.025n

.meas tran vdout0_11ck1850 FIND v(dout0_11) AT=930.025n

.meas tran vdout0_12ck1850 FIND v(dout0_12) AT=930.025n

.meas tran vdout0_13ck1850 FIND v(dout0_13) AT=930.025n

.meas tran vdout0_14ck1850 FIND v(dout0_14) AT=930.025n

.meas tran vdout0_15ck1850 FIND v(dout0_15) AT=930.025n

.meas tran vdout0_16ck1850 FIND v(dout0_16) AT=930.025n

.meas tran vdout0_17ck1850 FIND v(dout0_17) AT=930.025n

.meas tran vdout0_18ck1850 FIND v(dout0_18) AT=930.025n

.meas tran vdout0_19ck1850 FIND v(dout0_19) AT=930.025n

.meas tran vdout0_20ck1850 FIND v(dout0_20) AT=930.025n

.meas tran vdout0_21ck1850 FIND v(dout0_21) AT=930.025n

.meas tran vdout0_22ck1850 FIND v(dout0_22) AT=930.025n

.meas tran vdout0_23ck1850 FIND v(dout0_23) AT=930.025n

.meas tran vdout0_24ck1850 FIND v(dout0_24) AT=930.025n

.meas tran vdout0_25ck1850 FIND v(dout0_25) AT=930.025n

.meas tran vdout0_26ck1850 FIND v(dout0_26) AT=930.025n

.meas tran vdout0_27ck1850 FIND v(dout0_27) AT=930.025n

.meas tran vdout0_28ck1850 FIND v(dout0_28) AT=930.025n

.meas tran vdout0_29ck1850 FIND v(dout0_29) AT=930.025n

.meas tran vdout0_30ck1850 FIND v(dout0_30) AT=930.025n

.meas tran vdout0_31ck1850 FIND v(dout0_31) AT=930.025n

.meas tran vdout0_0ck1860 FIND v(dout0_0) AT=935.025n

.meas tran vdout0_1ck1860 FIND v(dout0_1) AT=935.025n

.meas tran vdout0_2ck1860 FIND v(dout0_2) AT=935.025n

.meas tran vdout0_3ck1860 FIND v(dout0_3) AT=935.025n

.meas tran vdout0_4ck1860 FIND v(dout0_4) AT=935.025n

.meas tran vdout0_5ck1860 FIND v(dout0_5) AT=935.025n

.meas tran vdout0_6ck1860 FIND v(dout0_6) AT=935.025n

.meas tran vdout0_7ck1860 FIND v(dout0_7) AT=935.025n

.meas tran vdout0_8ck1860 FIND v(dout0_8) AT=935.025n

.meas tran vdout0_9ck1860 FIND v(dout0_9) AT=935.025n

.meas tran vdout0_10ck1860 FIND v(dout0_10) AT=935.025n

.meas tran vdout0_11ck1860 FIND v(dout0_11) AT=935.025n

.meas tran vdout0_12ck1860 FIND v(dout0_12) AT=935.025n

.meas tran vdout0_13ck1860 FIND v(dout0_13) AT=935.025n

.meas tran vdout0_14ck1860 FIND v(dout0_14) AT=935.025n

.meas tran vdout0_15ck1860 FIND v(dout0_15) AT=935.025n

.meas tran vdout0_16ck1860 FIND v(dout0_16) AT=935.025n

.meas tran vdout0_17ck1860 FIND v(dout0_17) AT=935.025n

.meas tran vdout0_18ck1860 FIND v(dout0_18) AT=935.025n

.meas tran vdout0_19ck1860 FIND v(dout0_19) AT=935.025n

.meas tran vdout0_20ck1860 FIND v(dout0_20) AT=935.025n

.meas tran vdout0_21ck1860 FIND v(dout0_21) AT=935.025n

.meas tran vdout0_22ck1860 FIND v(dout0_22) AT=935.025n

.meas tran vdout0_23ck1860 FIND v(dout0_23) AT=935.025n

.meas tran vdout0_24ck1860 FIND v(dout0_24) AT=935.025n

.meas tran vdout0_25ck1860 FIND v(dout0_25) AT=935.025n

.meas tran vdout0_26ck1860 FIND v(dout0_26) AT=935.025n

.meas tran vdout0_27ck1860 FIND v(dout0_27) AT=935.025n

.meas tran vdout0_28ck1860 FIND v(dout0_28) AT=935.025n

.meas tran vdout0_29ck1860 FIND v(dout0_29) AT=935.025n

.meas tran vdout0_30ck1860 FIND v(dout0_30) AT=935.025n

.meas tran vdout0_31ck1860 FIND v(dout0_31) AT=935.025n

.meas tran vdout0_0ck1870 FIND v(dout0_0) AT=940.025n

.meas tran vdout0_1ck1870 FIND v(dout0_1) AT=940.025n

.meas tran vdout0_2ck1870 FIND v(dout0_2) AT=940.025n

.meas tran vdout0_3ck1870 FIND v(dout0_3) AT=940.025n

.meas tran vdout0_4ck1870 FIND v(dout0_4) AT=940.025n

.meas tran vdout0_5ck1870 FIND v(dout0_5) AT=940.025n

.meas tran vdout0_6ck1870 FIND v(dout0_6) AT=940.025n

.meas tran vdout0_7ck1870 FIND v(dout0_7) AT=940.025n

.meas tran vdout0_8ck1870 FIND v(dout0_8) AT=940.025n

.meas tran vdout0_9ck1870 FIND v(dout0_9) AT=940.025n

.meas tran vdout0_10ck1870 FIND v(dout0_10) AT=940.025n

.meas tran vdout0_11ck1870 FIND v(dout0_11) AT=940.025n

.meas tran vdout0_12ck1870 FIND v(dout0_12) AT=940.025n

.meas tran vdout0_13ck1870 FIND v(dout0_13) AT=940.025n

.meas tran vdout0_14ck1870 FIND v(dout0_14) AT=940.025n

.meas tran vdout0_15ck1870 FIND v(dout0_15) AT=940.025n

.meas tran vdout0_16ck1870 FIND v(dout0_16) AT=940.025n

.meas tran vdout0_17ck1870 FIND v(dout0_17) AT=940.025n

.meas tran vdout0_18ck1870 FIND v(dout0_18) AT=940.025n

.meas tran vdout0_19ck1870 FIND v(dout0_19) AT=940.025n

.meas tran vdout0_20ck1870 FIND v(dout0_20) AT=940.025n

.meas tran vdout0_21ck1870 FIND v(dout0_21) AT=940.025n

.meas tran vdout0_22ck1870 FIND v(dout0_22) AT=940.025n

.meas tran vdout0_23ck1870 FIND v(dout0_23) AT=940.025n

.meas tran vdout0_24ck1870 FIND v(dout0_24) AT=940.025n

.meas tran vdout0_25ck1870 FIND v(dout0_25) AT=940.025n

.meas tran vdout0_26ck1870 FIND v(dout0_26) AT=940.025n

.meas tran vdout0_27ck1870 FIND v(dout0_27) AT=940.025n

.meas tran vdout0_28ck1870 FIND v(dout0_28) AT=940.025n

.meas tran vdout0_29ck1870 FIND v(dout0_29) AT=940.025n

.meas tran vdout0_30ck1870 FIND v(dout0_30) AT=940.025n

.meas tran vdout0_31ck1870 FIND v(dout0_31) AT=940.025n

.meas tran vdout0_0ck1890 FIND v(dout0_0) AT=950.025n

.meas tran vdout0_1ck1890 FIND v(dout0_1) AT=950.025n

.meas tran vdout0_2ck1890 FIND v(dout0_2) AT=950.025n

.meas tran vdout0_3ck1890 FIND v(dout0_3) AT=950.025n

.meas tran vdout0_4ck1890 FIND v(dout0_4) AT=950.025n

.meas tran vdout0_5ck1890 FIND v(dout0_5) AT=950.025n

.meas tran vdout0_6ck1890 FIND v(dout0_6) AT=950.025n

.meas tran vdout0_7ck1890 FIND v(dout0_7) AT=950.025n

.meas tran vdout0_8ck1890 FIND v(dout0_8) AT=950.025n

.meas tran vdout0_9ck1890 FIND v(dout0_9) AT=950.025n

.meas tran vdout0_10ck1890 FIND v(dout0_10) AT=950.025n

.meas tran vdout0_11ck1890 FIND v(dout0_11) AT=950.025n

.meas tran vdout0_12ck1890 FIND v(dout0_12) AT=950.025n

.meas tran vdout0_13ck1890 FIND v(dout0_13) AT=950.025n

.meas tran vdout0_14ck1890 FIND v(dout0_14) AT=950.025n

.meas tran vdout0_15ck1890 FIND v(dout0_15) AT=950.025n

.meas tran vdout0_16ck1890 FIND v(dout0_16) AT=950.025n

.meas tran vdout0_17ck1890 FIND v(dout0_17) AT=950.025n

.meas tran vdout0_18ck1890 FIND v(dout0_18) AT=950.025n

.meas tran vdout0_19ck1890 FIND v(dout0_19) AT=950.025n

.meas tran vdout0_20ck1890 FIND v(dout0_20) AT=950.025n

.meas tran vdout0_21ck1890 FIND v(dout0_21) AT=950.025n

.meas tran vdout0_22ck1890 FIND v(dout0_22) AT=950.025n

.meas tran vdout0_23ck1890 FIND v(dout0_23) AT=950.025n

.meas tran vdout0_24ck1890 FIND v(dout0_24) AT=950.025n

.meas tran vdout0_25ck1890 FIND v(dout0_25) AT=950.025n

.meas tran vdout0_26ck1890 FIND v(dout0_26) AT=950.025n

.meas tran vdout0_27ck1890 FIND v(dout0_27) AT=950.025n

.meas tran vdout0_28ck1890 FIND v(dout0_28) AT=950.025n

.meas tran vdout0_29ck1890 FIND v(dout0_29) AT=950.025n

.meas tran vdout0_30ck1890 FIND v(dout0_30) AT=950.025n

.meas tran vdout0_31ck1890 FIND v(dout0_31) AT=950.025n

.meas tran vdout0_0ck1900 FIND v(dout0_0) AT=955.025n

.meas tran vdout0_1ck1900 FIND v(dout0_1) AT=955.025n

.meas tran vdout0_2ck1900 FIND v(dout0_2) AT=955.025n

.meas tran vdout0_3ck1900 FIND v(dout0_3) AT=955.025n

.meas tran vdout0_4ck1900 FIND v(dout0_4) AT=955.025n

.meas tran vdout0_5ck1900 FIND v(dout0_5) AT=955.025n

.meas tran vdout0_6ck1900 FIND v(dout0_6) AT=955.025n

.meas tran vdout0_7ck1900 FIND v(dout0_7) AT=955.025n

.meas tran vdout0_8ck1900 FIND v(dout0_8) AT=955.025n

.meas tran vdout0_9ck1900 FIND v(dout0_9) AT=955.025n

.meas tran vdout0_10ck1900 FIND v(dout0_10) AT=955.025n

.meas tran vdout0_11ck1900 FIND v(dout0_11) AT=955.025n

.meas tran vdout0_12ck1900 FIND v(dout0_12) AT=955.025n

.meas tran vdout0_13ck1900 FIND v(dout0_13) AT=955.025n

.meas tran vdout0_14ck1900 FIND v(dout0_14) AT=955.025n

.meas tran vdout0_15ck1900 FIND v(dout0_15) AT=955.025n

.meas tran vdout0_16ck1900 FIND v(dout0_16) AT=955.025n

.meas tran vdout0_17ck1900 FIND v(dout0_17) AT=955.025n

.meas tran vdout0_18ck1900 FIND v(dout0_18) AT=955.025n

.meas tran vdout0_19ck1900 FIND v(dout0_19) AT=955.025n

.meas tran vdout0_20ck1900 FIND v(dout0_20) AT=955.025n

.meas tran vdout0_21ck1900 FIND v(dout0_21) AT=955.025n

.meas tran vdout0_22ck1900 FIND v(dout0_22) AT=955.025n

.meas tran vdout0_23ck1900 FIND v(dout0_23) AT=955.025n

.meas tran vdout0_24ck1900 FIND v(dout0_24) AT=955.025n

.meas tran vdout0_25ck1900 FIND v(dout0_25) AT=955.025n

.meas tran vdout0_26ck1900 FIND v(dout0_26) AT=955.025n

.meas tran vdout0_27ck1900 FIND v(dout0_27) AT=955.025n

.meas tran vdout0_28ck1900 FIND v(dout0_28) AT=955.025n

.meas tran vdout0_29ck1900 FIND v(dout0_29) AT=955.025n

.meas tran vdout0_30ck1900 FIND v(dout0_30) AT=955.025n

.meas tran vdout0_31ck1900 FIND v(dout0_31) AT=955.025n

.meas tran vdout0_0ck1930 FIND v(dout0_0) AT=970.025n

.meas tran vdout0_1ck1930 FIND v(dout0_1) AT=970.025n

.meas tran vdout0_2ck1930 FIND v(dout0_2) AT=970.025n

.meas tran vdout0_3ck1930 FIND v(dout0_3) AT=970.025n

.meas tran vdout0_4ck1930 FIND v(dout0_4) AT=970.025n

.meas tran vdout0_5ck1930 FIND v(dout0_5) AT=970.025n

.meas tran vdout0_6ck1930 FIND v(dout0_6) AT=970.025n

.meas tran vdout0_7ck1930 FIND v(dout0_7) AT=970.025n

.meas tran vdout0_8ck1930 FIND v(dout0_8) AT=970.025n

.meas tran vdout0_9ck1930 FIND v(dout0_9) AT=970.025n

.meas tran vdout0_10ck1930 FIND v(dout0_10) AT=970.025n

.meas tran vdout0_11ck1930 FIND v(dout0_11) AT=970.025n

.meas tran vdout0_12ck1930 FIND v(dout0_12) AT=970.025n

.meas tran vdout0_13ck1930 FIND v(dout0_13) AT=970.025n

.meas tran vdout0_14ck1930 FIND v(dout0_14) AT=970.025n

.meas tran vdout0_15ck1930 FIND v(dout0_15) AT=970.025n

.meas tran vdout0_16ck1930 FIND v(dout0_16) AT=970.025n

.meas tran vdout0_17ck1930 FIND v(dout0_17) AT=970.025n

.meas tran vdout0_18ck1930 FIND v(dout0_18) AT=970.025n

.meas tran vdout0_19ck1930 FIND v(dout0_19) AT=970.025n

.meas tran vdout0_20ck1930 FIND v(dout0_20) AT=970.025n

.meas tran vdout0_21ck1930 FIND v(dout0_21) AT=970.025n

.meas tran vdout0_22ck1930 FIND v(dout0_22) AT=970.025n

.meas tran vdout0_23ck1930 FIND v(dout0_23) AT=970.025n

.meas tran vdout0_24ck1930 FIND v(dout0_24) AT=970.025n

.meas tran vdout0_25ck1930 FIND v(dout0_25) AT=970.025n

.meas tran vdout0_26ck1930 FIND v(dout0_26) AT=970.025n

.meas tran vdout0_27ck1930 FIND v(dout0_27) AT=970.025n

.meas tran vdout0_28ck1930 FIND v(dout0_28) AT=970.025n

.meas tran vdout0_29ck1930 FIND v(dout0_29) AT=970.025n

.meas tran vdout0_30ck1930 FIND v(dout0_30) AT=970.025n

.meas tran vdout0_31ck1930 FIND v(dout0_31) AT=970.025n

.meas tran vdout0_0ck1940 FIND v(dout0_0) AT=975.025n

.meas tran vdout0_1ck1940 FIND v(dout0_1) AT=975.025n

.meas tran vdout0_2ck1940 FIND v(dout0_2) AT=975.025n

.meas tran vdout0_3ck1940 FIND v(dout0_3) AT=975.025n

.meas tran vdout0_4ck1940 FIND v(dout0_4) AT=975.025n

.meas tran vdout0_5ck1940 FIND v(dout0_5) AT=975.025n

.meas tran vdout0_6ck1940 FIND v(dout0_6) AT=975.025n

.meas tran vdout0_7ck1940 FIND v(dout0_7) AT=975.025n

.meas tran vdout0_8ck1940 FIND v(dout0_8) AT=975.025n

.meas tran vdout0_9ck1940 FIND v(dout0_9) AT=975.025n

.meas tran vdout0_10ck1940 FIND v(dout0_10) AT=975.025n

.meas tran vdout0_11ck1940 FIND v(dout0_11) AT=975.025n

.meas tran vdout0_12ck1940 FIND v(dout0_12) AT=975.025n

.meas tran vdout0_13ck1940 FIND v(dout0_13) AT=975.025n

.meas tran vdout0_14ck1940 FIND v(dout0_14) AT=975.025n

.meas tran vdout0_15ck1940 FIND v(dout0_15) AT=975.025n

.meas tran vdout0_16ck1940 FIND v(dout0_16) AT=975.025n

.meas tran vdout0_17ck1940 FIND v(dout0_17) AT=975.025n

.meas tran vdout0_18ck1940 FIND v(dout0_18) AT=975.025n

.meas tran vdout0_19ck1940 FIND v(dout0_19) AT=975.025n

.meas tran vdout0_20ck1940 FIND v(dout0_20) AT=975.025n

.meas tran vdout0_21ck1940 FIND v(dout0_21) AT=975.025n

.meas tran vdout0_22ck1940 FIND v(dout0_22) AT=975.025n

.meas tran vdout0_23ck1940 FIND v(dout0_23) AT=975.025n

.meas tran vdout0_24ck1940 FIND v(dout0_24) AT=975.025n

.meas tran vdout0_25ck1940 FIND v(dout0_25) AT=975.025n

.meas tran vdout0_26ck1940 FIND v(dout0_26) AT=975.025n

.meas tran vdout0_27ck1940 FIND v(dout0_27) AT=975.025n

.meas tran vdout0_28ck1940 FIND v(dout0_28) AT=975.025n

.meas tran vdout0_29ck1940 FIND v(dout0_29) AT=975.025n

.meas tran vdout0_30ck1940 FIND v(dout0_30) AT=975.025n

.meas tran vdout0_31ck1940 FIND v(dout0_31) AT=975.025n

.meas tran vdout0_0ck1960 FIND v(dout0_0) AT=985.025n

.meas tran vdout0_1ck1960 FIND v(dout0_1) AT=985.025n

.meas tran vdout0_2ck1960 FIND v(dout0_2) AT=985.025n

.meas tran vdout0_3ck1960 FIND v(dout0_3) AT=985.025n

.meas tran vdout0_4ck1960 FIND v(dout0_4) AT=985.025n

.meas tran vdout0_5ck1960 FIND v(dout0_5) AT=985.025n

.meas tran vdout0_6ck1960 FIND v(dout0_6) AT=985.025n

.meas tran vdout0_7ck1960 FIND v(dout0_7) AT=985.025n

.meas tran vdout0_8ck1960 FIND v(dout0_8) AT=985.025n

.meas tran vdout0_9ck1960 FIND v(dout0_9) AT=985.025n

.meas tran vdout0_10ck1960 FIND v(dout0_10) AT=985.025n

.meas tran vdout0_11ck1960 FIND v(dout0_11) AT=985.025n

.meas tran vdout0_12ck1960 FIND v(dout0_12) AT=985.025n

.meas tran vdout0_13ck1960 FIND v(dout0_13) AT=985.025n

.meas tran vdout0_14ck1960 FIND v(dout0_14) AT=985.025n

.meas tran vdout0_15ck1960 FIND v(dout0_15) AT=985.025n

.meas tran vdout0_16ck1960 FIND v(dout0_16) AT=985.025n

.meas tran vdout0_17ck1960 FIND v(dout0_17) AT=985.025n

.meas tran vdout0_18ck1960 FIND v(dout0_18) AT=985.025n

.meas tran vdout0_19ck1960 FIND v(dout0_19) AT=985.025n

.meas tran vdout0_20ck1960 FIND v(dout0_20) AT=985.025n

.meas tran vdout0_21ck1960 FIND v(dout0_21) AT=985.025n

.meas tran vdout0_22ck1960 FIND v(dout0_22) AT=985.025n

.meas tran vdout0_23ck1960 FIND v(dout0_23) AT=985.025n

.meas tran vdout0_24ck1960 FIND v(dout0_24) AT=985.025n

.meas tran vdout0_25ck1960 FIND v(dout0_25) AT=985.025n

.meas tran vdout0_26ck1960 FIND v(dout0_26) AT=985.025n

.meas tran vdout0_27ck1960 FIND v(dout0_27) AT=985.025n

.meas tran vdout0_28ck1960 FIND v(dout0_28) AT=985.025n

.meas tran vdout0_29ck1960 FIND v(dout0_29) AT=985.025n

.meas tran vdout0_30ck1960 FIND v(dout0_30) AT=985.025n

.meas tran vdout0_31ck1960 FIND v(dout0_31) AT=985.025n

.meas tran vdout0_0ck1990 FIND v(dout0_0) AT=1000.025n

.meas tran vdout0_1ck1990 FIND v(dout0_1) AT=1000.025n

.meas tran vdout0_2ck1990 FIND v(dout0_2) AT=1000.025n

.meas tran vdout0_3ck1990 FIND v(dout0_3) AT=1000.025n

.meas tran vdout0_4ck1990 FIND v(dout0_4) AT=1000.025n

.meas tran vdout0_5ck1990 FIND v(dout0_5) AT=1000.025n

.meas tran vdout0_6ck1990 FIND v(dout0_6) AT=1000.025n

.meas tran vdout0_7ck1990 FIND v(dout0_7) AT=1000.025n

.meas tran vdout0_8ck1990 FIND v(dout0_8) AT=1000.025n

.meas tran vdout0_9ck1990 FIND v(dout0_9) AT=1000.025n

.meas tran vdout0_10ck1990 FIND v(dout0_10) AT=1000.025n

.meas tran vdout0_11ck1990 FIND v(dout0_11) AT=1000.025n

.meas tran vdout0_12ck1990 FIND v(dout0_12) AT=1000.025n

.meas tran vdout0_13ck1990 FIND v(dout0_13) AT=1000.025n

.meas tran vdout0_14ck1990 FIND v(dout0_14) AT=1000.025n

.meas tran vdout0_15ck1990 FIND v(dout0_15) AT=1000.025n

.meas tran vdout0_16ck1990 FIND v(dout0_16) AT=1000.025n

.meas tran vdout0_17ck1990 FIND v(dout0_17) AT=1000.025n

.meas tran vdout0_18ck1990 FIND v(dout0_18) AT=1000.025n

.meas tran vdout0_19ck1990 FIND v(dout0_19) AT=1000.025n

.meas tran vdout0_20ck1990 FIND v(dout0_20) AT=1000.025n

.meas tran vdout0_21ck1990 FIND v(dout0_21) AT=1000.025n

.meas tran vdout0_22ck1990 FIND v(dout0_22) AT=1000.025n

.meas tran vdout0_23ck1990 FIND v(dout0_23) AT=1000.025n

.meas tran vdout0_24ck1990 FIND v(dout0_24) AT=1000.025n

.meas tran vdout0_25ck1990 FIND v(dout0_25) AT=1000.025n

.meas tran vdout0_26ck1990 FIND v(dout0_26) AT=1000.025n

.meas tran vdout0_27ck1990 FIND v(dout0_27) AT=1000.025n

.meas tran vdout0_28ck1990 FIND v(dout0_28) AT=1000.025n

.meas tran vdout0_29ck1990 FIND v(dout0_29) AT=1000.025n

.meas tran vdout0_30ck1990 FIND v(dout0_30) AT=1000.025n

.meas tran vdout0_31ck1990 FIND v(dout0_31) AT=1000.025n

.meas tran vdout0_0ck2000 FIND v(dout0_0) AT=1005.025n

.meas tran vdout0_1ck2000 FIND v(dout0_1) AT=1005.025n

.meas tran vdout0_2ck2000 FIND v(dout0_2) AT=1005.025n

.meas tran vdout0_3ck2000 FIND v(dout0_3) AT=1005.025n

.meas tran vdout0_4ck2000 FIND v(dout0_4) AT=1005.025n

.meas tran vdout0_5ck2000 FIND v(dout0_5) AT=1005.025n

.meas tran vdout0_6ck2000 FIND v(dout0_6) AT=1005.025n

.meas tran vdout0_7ck2000 FIND v(dout0_7) AT=1005.025n

.meas tran vdout0_8ck2000 FIND v(dout0_8) AT=1005.025n

.meas tran vdout0_9ck2000 FIND v(dout0_9) AT=1005.025n

.meas tran vdout0_10ck2000 FIND v(dout0_10) AT=1005.025n

.meas tran vdout0_11ck2000 FIND v(dout0_11) AT=1005.025n

.meas tran vdout0_12ck2000 FIND v(dout0_12) AT=1005.025n

.meas tran vdout0_13ck2000 FIND v(dout0_13) AT=1005.025n

.meas tran vdout0_14ck2000 FIND v(dout0_14) AT=1005.025n

.meas tran vdout0_15ck2000 FIND v(dout0_15) AT=1005.025n

.meas tran vdout0_16ck2000 FIND v(dout0_16) AT=1005.025n

.meas tran vdout0_17ck2000 FIND v(dout0_17) AT=1005.025n

.meas tran vdout0_18ck2000 FIND v(dout0_18) AT=1005.025n

.meas tran vdout0_19ck2000 FIND v(dout0_19) AT=1005.025n

.meas tran vdout0_20ck2000 FIND v(dout0_20) AT=1005.025n

.meas tran vdout0_21ck2000 FIND v(dout0_21) AT=1005.025n

.meas tran vdout0_22ck2000 FIND v(dout0_22) AT=1005.025n

.meas tran vdout0_23ck2000 FIND v(dout0_23) AT=1005.025n

.meas tran vdout0_24ck2000 FIND v(dout0_24) AT=1005.025n

.meas tran vdout0_25ck2000 FIND v(dout0_25) AT=1005.025n

.meas tran vdout0_26ck2000 FIND v(dout0_26) AT=1005.025n

.meas tran vdout0_27ck2000 FIND v(dout0_27) AT=1005.025n

.meas tran vdout0_28ck2000 FIND v(dout0_28) AT=1005.025n

.meas tran vdout0_29ck2000 FIND v(dout0_29) AT=1005.025n

.meas tran vdout0_30ck2000 FIND v(dout0_30) AT=1005.025n

.meas tran vdout0_31ck2000 FIND v(dout0_31) AT=1005.025n

.meas tran vdout0_0ck2010 FIND v(dout0_0) AT=1010.025n

.meas tran vdout0_1ck2010 FIND v(dout0_1) AT=1010.025n

.meas tran vdout0_2ck2010 FIND v(dout0_2) AT=1010.025n

.meas tran vdout0_3ck2010 FIND v(dout0_3) AT=1010.025n

.meas tran vdout0_4ck2010 FIND v(dout0_4) AT=1010.025n

.meas tran vdout0_5ck2010 FIND v(dout0_5) AT=1010.025n

.meas tran vdout0_6ck2010 FIND v(dout0_6) AT=1010.025n

.meas tran vdout0_7ck2010 FIND v(dout0_7) AT=1010.025n

.meas tran vdout0_8ck2010 FIND v(dout0_8) AT=1010.025n

.meas tran vdout0_9ck2010 FIND v(dout0_9) AT=1010.025n

.meas tran vdout0_10ck2010 FIND v(dout0_10) AT=1010.025n

.meas tran vdout0_11ck2010 FIND v(dout0_11) AT=1010.025n

.meas tran vdout0_12ck2010 FIND v(dout0_12) AT=1010.025n

.meas tran vdout0_13ck2010 FIND v(dout0_13) AT=1010.025n

.meas tran vdout0_14ck2010 FIND v(dout0_14) AT=1010.025n

.meas tran vdout0_15ck2010 FIND v(dout0_15) AT=1010.025n

.meas tran vdout0_16ck2010 FIND v(dout0_16) AT=1010.025n

.meas tran vdout0_17ck2010 FIND v(dout0_17) AT=1010.025n

.meas tran vdout0_18ck2010 FIND v(dout0_18) AT=1010.025n

.meas tran vdout0_19ck2010 FIND v(dout0_19) AT=1010.025n

.meas tran vdout0_20ck2010 FIND v(dout0_20) AT=1010.025n

.meas tran vdout0_21ck2010 FIND v(dout0_21) AT=1010.025n

.meas tran vdout0_22ck2010 FIND v(dout0_22) AT=1010.025n

.meas tran vdout0_23ck2010 FIND v(dout0_23) AT=1010.025n

.meas tran vdout0_24ck2010 FIND v(dout0_24) AT=1010.025n

.meas tran vdout0_25ck2010 FIND v(dout0_25) AT=1010.025n

.meas tran vdout0_26ck2010 FIND v(dout0_26) AT=1010.025n

.meas tran vdout0_27ck2010 FIND v(dout0_27) AT=1010.025n

.meas tran vdout0_28ck2010 FIND v(dout0_28) AT=1010.025n

.meas tran vdout0_29ck2010 FIND v(dout0_29) AT=1010.025n

.meas tran vdout0_30ck2010 FIND v(dout0_30) AT=1010.025n

.meas tran vdout0_31ck2010 FIND v(dout0_31) AT=1010.025n

.meas tran vdout0_0ck2020 FIND v(dout0_0) AT=1015.025n

.meas tran vdout0_1ck2020 FIND v(dout0_1) AT=1015.025n

.meas tran vdout0_2ck2020 FIND v(dout0_2) AT=1015.025n

.meas tran vdout0_3ck2020 FIND v(dout0_3) AT=1015.025n

.meas tran vdout0_4ck2020 FIND v(dout0_4) AT=1015.025n

.meas tran vdout0_5ck2020 FIND v(dout0_5) AT=1015.025n

.meas tran vdout0_6ck2020 FIND v(dout0_6) AT=1015.025n

.meas tran vdout0_7ck2020 FIND v(dout0_7) AT=1015.025n

.meas tran vdout0_8ck2020 FIND v(dout0_8) AT=1015.025n

.meas tran vdout0_9ck2020 FIND v(dout0_9) AT=1015.025n

.meas tran vdout0_10ck2020 FIND v(dout0_10) AT=1015.025n

.meas tran vdout0_11ck2020 FIND v(dout0_11) AT=1015.025n

.meas tran vdout0_12ck2020 FIND v(dout0_12) AT=1015.025n

.meas tran vdout0_13ck2020 FIND v(dout0_13) AT=1015.025n

.meas tran vdout0_14ck2020 FIND v(dout0_14) AT=1015.025n

.meas tran vdout0_15ck2020 FIND v(dout0_15) AT=1015.025n

.meas tran vdout0_16ck2020 FIND v(dout0_16) AT=1015.025n

.meas tran vdout0_17ck2020 FIND v(dout0_17) AT=1015.025n

.meas tran vdout0_18ck2020 FIND v(dout0_18) AT=1015.025n

.meas tran vdout0_19ck2020 FIND v(dout0_19) AT=1015.025n

.meas tran vdout0_20ck2020 FIND v(dout0_20) AT=1015.025n

.meas tran vdout0_21ck2020 FIND v(dout0_21) AT=1015.025n

.meas tran vdout0_22ck2020 FIND v(dout0_22) AT=1015.025n

.meas tran vdout0_23ck2020 FIND v(dout0_23) AT=1015.025n

.meas tran vdout0_24ck2020 FIND v(dout0_24) AT=1015.025n

.meas tran vdout0_25ck2020 FIND v(dout0_25) AT=1015.025n

.meas tran vdout0_26ck2020 FIND v(dout0_26) AT=1015.025n

.meas tran vdout0_27ck2020 FIND v(dout0_27) AT=1015.025n

.meas tran vdout0_28ck2020 FIND v(dout0_28) AT=1015.025n

.meas tran vdout0_29ck2020 FIND v(dout0_29) AT=1015.025n

.meas tran vdout0_30ck2020 FIND v(dout0_30) AT=1015.025n

.meas tran vdout0_31ck2020 FIND v(dout0_31) AT=1015.025n

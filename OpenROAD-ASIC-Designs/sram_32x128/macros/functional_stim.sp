* Functional test stimulus file for 5ns period

* TT process corner
.include "/home/ivann/OpenRAM/technology/freepdk45/models/tran_models/models_nom/PMOS_VTG.inc"
.include "/home/ivann/OpenRAM/technology/freepdk45/models/tran_models/models_nom/NMOS_VTG.inc"
.include "/home/ivann/OpenRAM/tmp/sram.sp"

* Global Power Supplies
Vvdd vdd 0 1.1

*Nodes gnd and 0 are the same global ground node in ngspice/hspice/xa. Otherwise, this source may be needed.
*Vgnd gnd 0 0.0

* Instantiation of the SRAM
XSRAM_32x128_1rw din0_0 din0_1 din0_2 din0_3 din0_4 din0_5 din0_6 din0_7 din0_8 din0_9 din0_10 din0_11 din0_12 din0_13 din0_14 din0_15 din0_16 din0_17 din0_18 din0_19 din0_20 din0_21 din0_22 din0_23 din0_24 din0_25 din0_26 din0_27 din0_28 din0_29 din0_30 din0_31 a0_0 a0_1 a0_2 a0_3 a0_4 a0_5 a0_6 CSB0 WEB0 clk0 dout0_0 dout0_1 dout0_2 dout0_3 dout0_4 dout0_5 dout0_6 dout0_7 dout0_8 dout0_9 dout0_10 dout0_11 dout0_12 dout0_13 dout0_14 dout0_15 dout0_16 dout0_17 dout0_18 dout0_19 dout0_20 dout0_21 dout0_22 dout0_23 dout0_24 dout0_25 dout0_26 dout0_27 dout0_28 dout0_29 dout0_30 dout0_31 vdd gnd SRAM_32x128_1rw

* SRAM output loads
CD00 dout0_0  0 0.8364f
CD01 dout0_1  0 0.8364f
CD02 dout0_2  0 0.8364f
CD03 dout0_3  0 0.8364f
CD04 dout0_4  0 0.8364f
CD05 dout0_5  0 0.8364f
CD06 dout0_6  0 0.8364f
CD07 dout0_7  0 0.8364f
CD08 dout0_8  0 0.8364f
CD09 dout0_9  0 0.8364f
CD010 dout0_10  0 0.8364f
CD011 dout0_11  0 0.8364f
CD012 dout0_12  0 0.8364f
CD013 dout0_13  0 0.8364f
CD014 dout0_14  0 0.8364f
CD015 dout0_15  0 0.8364f
CD016 dout0_16  0 0.8364f
CD017 dout0_17  0 0.8364f
CD018 dout0_18  0 0.8364f
CD019 dout0_19  0 0.8364f
CD020 dout0_20  0 0.8364f
CD021 dout0_21  0 0.8364f
CD022 dout0_22  0 0.8364f
CD023 dout0_23  0 0.8364f
CD024 dout0_24  0 0.8364f
CD025 dout0_25  0 0.8364f
CD026 dout0_26  0 0.8364f
CD027 dout0_27  0 0.8364f
CD028 dout0_28  0 0.8364f
CD029 dout0_29  0 0.8364f
CD030 dout0_30  0 0.8364f
CD031 dout0_31  0 0.8364f

* Important signals for debug
* bl:	xsram:xbank0:bl_0_0
* br:	xsram:xbank0:br_0_0
* s_en:	xsram:s_en
* q:	xsram:xbank0:xbitcell_array:xbitcell_array:xbit_r0_c0.Q
* qbar:	xsram:xbank0:xbitcell_array:xbitcell_array:xbit_r0_c0.Q_bar

* Sequence of operations
*	Idle during cycle 0 (0ns - 5ns)
*	Writing 00111010011111110111010001111110  to  address 0000010 (from port 0) during cycle 1 (5ns - 10ns)
*	Writing 10111110011010010000111100001011  to  address 0000000 (from port 0) during cycle 2 (10ns - 15ns)
*	Writing 00100111000001111001110101111011  to  address 0000000 (from port 0) during cycle 3 (15ns - 20ns)
*	Reading 00100111000001111001110101111011 from address 0000000 (from port 0) during cycle 4 (20ns - 25ns)
*	Reading 00111010011111110111010001111110 from address 0000010 (from port 0) during cycle 5 (25ns - 30ns)
*	Writing 00001000001111001100010000001010  to  address 0000000 (from port 0) during cycle 6 (30ns - 35ns)
*	Writing 11101001110101001100011100111101  to  address 0000001 (from port 0) during cycle 7 (35ns - 40ns)
*	Writing 11100010101011011000011011010001  to  address 0000011 (from port 0) during cycle 8 (40ns - 45ns)
*	Reading 11101001110101001100011100111101 from address 0000001 (from port 0) during cycle 9 (45ns - 50ns)
*	Reading 00111010011111110111010001111110 from address 0000010 (from port 0) during cycle 10 (50ns - 55ns)
*	Reading 00111010011111110111010001111110 from address 0000010 (from port 0) during cycle 11 (55ns - 60ns)
*	Writing 11000111111001001101000110101111  to  address 1111110 (from port 0) during cycle 12 (60ns - 65ns)
*	Reading 11100010101011011000011011010001 from address 0000011 (from port 0) during cycle 13 (65ns - 70ns)
*	Writing 10111100110101001111111011010000  to  address 1111101 (from port 0) during cycle 14 (70ns - 75ns)
*	Reading 11101001110101001100011100111101 from address 0000001 (from port 0) during cycle 17 (85ns - 90ns)
*	Reading 00111010011111110111010001111110 from address 0000010 (from port 0) during cycle 18 (90ns - 95ns)
*	Writing 11000000000101100011100001100111  to  address 0000000 (from port 0) during cycle 20 (100ns - 105ns)
*	Reading 10111100110101001111111011010000 from address 1111101 (from port 0) during cycle 22 (110ns - 115ns)
*	Writing 01011111100001001100010101111010  to  address 0000010 (from port 0) during cycle 23 (115ns - 120ns)
*	Writing 10110001110010010011011000101101  to  address 0000011 (from port 0) during cycle 25 (125ns - 130ns)
*	Reading 11000000000101100011100001100111 from address 0000000 (from port 0) during cycle 26 (130ns - 135ns)
*	Writing 01000110101010110001011001111111  to  address 1111101 (from port 0) during cycle 27 (135ns - 140ns)
*	Writing 10101101000111011001010100111110  to  address 0000001 (from port 0) during cycle 28 (140ns - 145ns)
*	Writing 01101101110010000101100100000101  to  address 0000000 (from port 0) during cycle 29 (145ns - 150ns)
*	Reading 01011111100001001100010101111010 from address 0000010 (from port 0) during cycle 32 (160ns - 165ns)
*	Writing 11011110110101100010101100011001  to  address 0000011 (from port 0) during cycle 33 (165ns - 170ns)
*	Reading 10101101000111011001010100111110 from address 0000001 (from port 0) during cycle 34 (170ns - 175ns)
*	Reading 01101101110010000101100100000101 from address 0000000 (from port 0) during cycle 35 (175ns - 180ns)
*	Reading 10101101000111011001010100111110 from address 0000001 (from port 0) during cycle 37 (185ns - 190ns)
*	Reading 01000110101010110001011001111111 from address 1111101 (from port 0) during cycle 39 (195ns - 200ns)
*	Writing 00010011101101000000011100010101  to  address 1111011 (from port 0) during cycle 40 (200ns - 205ns)
*	Reading 01000110101010110001011001111111 from address 1111101 (from port 0) during cycle 43 (215ns - 220ns)
*	Writing 11110110010110111001001111001001  to  address 0000011 (from port 0) during cycle 44 (220ns - 225ns)
*	Reading 11110110010110111001001111001001 from address 0000011 (from port 0) during cycle 45 (225ns - 230ns)
*	Writing 00101001001111010000100010110001  to  address 1111100 (from port 0) during cycle 46 (230ns - 235ns)
*	Writing 01001110000001100100100011010101  to  address 0000001 (from port 0) during cycle 49 (245ns - 250ns)
*	Writing 11100110101111010000111101110011  to  address 0000010 (from port 0) during cycle 51 (255ns - 260ns)
*	Reading 01000110101010110001011001111111 from address 1111101 (from port 0) during cycle 53 (265ns - 270ns)
*	Writing 10110001100100100100110011001000  to  address 1111011 (from port 0) during cycle 54 (270ns - 275ns)
*	Reading 11110110010110111001001111001001 from address 0000011 (from port 0) during cycle 55 (275ns - 280ns)
*	Reading 01000110101010110001011001111111 from address 1111101 (from port 0) during cycle 56 (280ns - 285ns)
*	Writing 10001101110111000101001010110101  to  address 0000000 (from port 0) during cycle 57 (285ns - 290ns)
*	Reading 01001110000001100100100011010101 from address 0000001 (from port 0) during cycle 58 (290ns - 295ns)
*	Reading 11000111111001001101000110101111 from address 1111110 (from port 0) during cycle 59 (295ns - 300ns)
*	Reading 11000111111001001101000110101111 from address 1111110 (from port 0) during cycle 60 (300ns - 305ns)
*	Writing 10100011011101111001111001010110  to  address 0000000 (from port 0) during cycle 61 (305ns - 310ns)
*	Reading 00101001001111010000100010110001 from address 1111100 (from port 0) during cycle 63 (315ns - 320ns)
*	Writing 01111100001110010101110110000010  to  address 1111110 (from port 0) during cycle 65 (325ns - 330ns)
*	Writing 11011001000011010110010100111110  to  address 1111110 (from port 0) during cycle 66 (330ns - 335ns)
*	Reading 11011001000011010110010100111110 from address 1111110 (from port 0) during cycle 67 (335ns - 340ns)
*	Reading 00101001001111010000100010110001 from address 1111100 (from port 0) during cycle 68 (340ns - 345ns)
*	Writing 01100001100011101001110010011101  to  address 1111011 (from port 0) during cycle 69 (345ns - 350ns)
*	Reading 01100001100011101001110010011101 from address 1111011 (from port 0) during cycle 70 (350ns - 355ns)
*	Reading 01000110101010110001011001111111 from address 1111101 (from port 0) during cycle 71 (355ns - 360ns)
*	Reading 01100001100011101001110010011101 from address 1111011 (from port 0) during cycle 72 (360ns - 365ns)
*	Writing 11001111000111101110011010000000  to  address 0000000 (from port 0) during cycle 74 (370ns - 375ns)
*	Writing 01111110101101101100110001010101  to  address 0000001 (from port 0) during cycle 75 (375ns - 380ns)
*	Writing 00000000010111100111000111000010  to  address 1111100 (from port 0) during cycle 77 (385ns - 390ns)
*	Reading 11001111000111101110011010000000 from address 0000000 (from port 0) during cycle 81 (405ns - 410ns)
*	Reading 01100001100011101001110010011101 from address 1111011 (from port 0) during cycle 82 (410ns - 415ns)
*	Writing 11001011011000001100110101101111  to  address 0000001 (from port 0) during cycle 83 (415ns - 420ns)
*	Writing 11010011100001011101001100111000  to  address 1111110 (from port 0) during cycle 84 (420ns - 425ns)
*	Reading 11001111000111101110011010000000 from address 0000000 (from port 0) during cycle 85 (425ns - 430ns)
*	Writing 00100111011000011011100110010101  to  address 0000001 (from port 0) during cycle 86 (430ns - 435ns)
*	Reading 11001111000111101110011010000000 from address 0000000 (from port 0) during cycle 87 (435ns - 440ns)
*	Reading 11110110010110111001001111001001 from address 0000011 (from port 0) during cycle 89 (445ns - 450ns)
*	Reading 11001111000111101110011010000000 from address 0000000 (from port 0) during cycle 90 (450ns - 455ns)
*	Reading 11010011100001011101001100111000 from address 1111110 (from port 0) during cycle 91 (455ns - 460ns)
*	Reading 11100110101111010000111101110011 from address 0000010 (from port 0) during cycle 92 (460ns - 465ns)
*	Reading 11110110010110111001001111001001 from address 0000011 (from port 0) during cycle 93 (465ns - 470ns)
*	Reading 11001111000111101110011010000000 from address 0000000 (from port 0) during cycle 94 (470ns - 475ns)
*	Reading 01000110101010110001011001111111 from address 1111101 (from port 0) during cycle 95 (475ns - 480ns)
*	Writing 10000100111010101111011110000101  to  address 0000000 (from port 0) during cycle 96 (480ns - 485ns)
*	Writing 11010101111100000011100111011101  to  address 1111100 (from port 0) during cycle 97 (485ns - 490ns)
*	Writing 00001110011110000001011111001001  to  address 0000001 (from port 0) during cycle 99 (495ns - 500ns)
*	Reading 01100001100011101001110010011101 from address 1111011 (from port 0) during cycle 100 (500ns - 505ns)
*	Reading 11110110010110111001001111001001 from address 0000011 (from port 0) during cycle 101 (505ns - 510ns)
*	Reading 11100110101111010000111101110011 from address 0000010 (from port 0) during cycle 102 (510ns - 515ns)
*	Writing 11001110000001100000010111110101  to  address 1111100 (from port 0) during cycle 104 (520ns - 525ns)
*	Writing 00010011110111010111101110010110  to  address 1111110 (from port 0) during cycle 107 (535ns - 540ns)
*	Writing 11010100100000000110000100011111  to  address 1111110 (from port 0) during cycle 108 (540ns - 545ns)
*	Writing 11100110111000100000010001011110  to  address 0000010 (from port 0) during cycle 111 (555ns - 560ns)
*	Reading 01100001100011101001110010011101 from address 1111011 (from port 0) during cycle 112 (560ns - 565ns)
*	Reading 11100110111000100000010001011110 from address 0000010 (from port 0) during cycle 113 (565ns - 570ns)
*	Writing 00000001000100011001110001001000  to  address 0000011 (from port 0) during cycle 114 (570ns - 575ns)
*	Reading 00000001000100011001110001001000 from address 0000011 (from port 0) during cycle 116 (580ns - 585ns)
*	Writing 01100110111001001111010000001001  to  address 0000011 (from port 0) during cycle 117 (585ns - 590ns)
*	Reading 01100110111001001111010000001001 from address 0000011 (from port 0) during cycle 119 (595ns - 600ns)
*	Writing 01101000001100001000110111001101  to  address 1111100 (from port 0) during cycle 120 (600ns - 605ns)
*	Reading 10000100111010101111011110000101 from address 0000000 (from port 0) during cycle 121 (605ns - 610ns)
*	Reading 10000100111010101111011110000101 from address 0000000 (from port 0) during cycle 122 (610ns - 615ns)
*	Writing 00011111001100010000111110100100  to  address 0000010 (from port 0) during cycle 124 (620ns - 625ns)
*	Reading 00011111001100010000111110100100 from address 0000010 (from port 0) during cycle 125 (625ns - 630ns)
*	Reading 01100001100011101001110010011101 from address 1111011 (from port 0) during cycle 126 (630ns - 635ns)
*	Reading 00011111001100010000111110100100 from address 0000010 (from port 0) during cycle 127 (635ns - 640ns)
*	Reading 00001110011110000001011111001001 from address 0000001 (from port 0) during cycle 128 (640ns - 645ns)
*	Reading 00011111001100010000111110100100 from address 0000010 (from port 0) during cycle 129 (645ns - 650ns)
*	Writing 10001110101111101001111110010111  to  address 0000010 (from port 0) during cycle 130 (650ns - 655ns)
*	Writing 00111110110110000110100100100111  to  address 0000010 (from port 0) during cycle 131 (655ns - 660ns)
*	Reading 01101000001100001000110111001101 from address 1111100 (from port 0) during cycle 133 (665ns - 670ns)
*	Reading 11010100100000000110000100011111 from address 1111110 (from port 0) during cycle 134 (670ns - 675ns)
*	Reading 00001110011110000001011111001001 from address 0000001 (from port 0) during cycle 137 (685ns - 690ns)
*	Writing 01000011011001010100101100110010  to  address 0000000 (from port 0) during cycle 138 (690ns - 695ns)
*	Reading 00001110011110000001011111001001 from address 0000001 (from port 0) during cycle 139 (695ns - 700ns)
*	Writing 00110000100101111101110011110100  to  address 0000001 (from port 0) during cycle 143 (715ns - 720ns)
*	Reading 00110000100101111101110011110100 from address 0000001 (from port 0) during cycle 144 (720ns - 725ns)
*	Writing 10110111001111000011000011001000  to  address 1111100 (from port 0) during cycle 145 (725ns - 730ns)
*	Reading 00110000100101111101110011110100 from address 0000001 (from port 0) during cycle 146 (730ns - 735ns)
*	Reading 01000011011001010100101100110010 from address 0000000 (from port 0) during cycle 150 (750ns - 755ns)
*	Reading 01100001100011101001110010011101 from address 1111011 (from port 0) during cycle 151 (755ns - 760ns)
*	Reading 00111110110110000110100100100111 from address 0000010 (from port 0) during cycle 152 (760ns - 765ns)
*	Reading 01100110111001001111010000001001 from address 0000011 (from port 0) during cycle 153 (765ns - 770ns)
*	Reading 01100001100011101001110010011101 from address 1111011 (from port 0) during cycle 154 (770ns - 775ns)
*	Reading 01100110111001001111010000001001 from address 0000011 (from port 0) during cycle 156 (780ns - 785ns)
*	Reading 00111110110110000110100100100111 from address 0000010 (from port 0) during cycle 157 (785ns - 790ns)
*	Reading 01000011011001010100101100110010 from address 0000000 (from port 0) during cycle 158 (790ns - 795ns)
*	Writing 11011001011001101110110100111011  to  address 0000000 (from port 0) during cycle 159 (795ns - 800ns)
*	Reading 00111110110110000110100100100111 from address 0000010 (from port 0) during cycle 162 (810ns - 815ns)
*	Reading 01100110111001001111010000001001 from address 0000011 (from port 0) during cycle 163 (815ns - 820ns)
*	Reading 00110000100101111101110011110100 from address 0000001 (from port 0) during cycle 164 (820ns - 825ns)
*	Reading 10110111001111000011000011001000 from address 1111100 (from port 0) during cycle 166 (830ns - 835ns)
*	Reading 01100001100011101001110010011101 from address 1111011 (from port 0) during cycle 167 (835ns - 840ns)
*	Writing 11100010001011000100011100101100  to  address 1111110 (from port 0) during cycle 168 (840ns - 845ns)
*	Reading 01100001100011101001110010011101 from address 1111011 (from port 0) during cycle 171 (855ns - 860ns)
*	Reading 00111110110110000110100100100111 from address 0000010 (from port 0) during cycle 172 (860ns - 865ns)
*	Reading 00110000100101111101110011110100 from address 0000001 (from port 0) during cycle 173 (865ns - 870ns)
*	Writing 01010010111101101000101111011111  to  address 1111110 (from port 0) during cycle 174 (870ns - 875ns)
*	Reading 10110111001111000011000011001000 from address 1111100 (from port 0) during cycle 175 (875ns - 880ns)
*	Reading 00110000100101111101110011110100 from address 0000001 (from port 0) during cycle 176 (880ns - 885ns)
*	Writing 00101011011100100010010010110010  to  address 0000011 (from port 0) during cycle 179 (895ns - 900ns)
*	Reading 00110000100101111101110011110100 from address 0000001 (from port 0) during cycle 180 (900ns - 905ns)
*	Reading 00101011011100100010010010110010 from address 0000011 (from port 0) during cycle 181 (905ns - 910ns)
*	Reading 11011001011001101110110100111011 from address 0000000 (from port 0) during cycle 182 (910ns - 915ns)
*	Reading 01010010111101101000101111011111 from address 1111110 (from port 0) during cycle 183 (915ns - 920ns)
*	Writing 10101111010100110111011000000100  to  address 0000000 (from port 0) during cycle 184 (920ns - 925ns)
*	Reading 00101011011100100010010010110010 from address 0000011 (from port 0) during cycle 185 (925ns - 930ns)
*	Reading 01010010111101101000101111011111 from address 1111110 (from port 0) during cycle 186 (930ns - 935ns)
*	Reading 01010010111101101000101111011111 from address 1111110 (from port 0) during cycle 187 (935ns - 940ns)
*	Writing 01101010100110111001110101011100  to  address 0000010 (from port 0) during cycle 188 (940ns - 945ns)
*	Reading 01101010100110111001110101011100 from address 0000010 (from port 0) during cycle 189 (945ns - 950ns)
*	Reading 10101111010100110111011000000100 from address 0000000 (from port 0) during cycle 190 (950ns - 955ns)
*	Reading 01010010111101101000101111011111 from address 1111110 (from port 0) during cycle 193 (965ns - 970ns)
*	Reading 01000110101010110001011001111111 from address 1111101 (from port 0) during cycle 194 (970ns - 975ns)
*	Reading 10110111001111000011000011001000 from address 1111100 (from port 0) during cycle 196 (980ns - 985ns)
*	Writing 00000010110100001000000111101111  to  address 0000001 (from port 0) during cycle 197 (985ns - 990ns)
*	Writing 11101100000111101010000011000011  to  address 1111011 (from port 0) during cycle 198 (990ns - 995ns)
*	Reading 01010010111101101000101111011111 from address 1111110 (from port 0) during cycle 199 (995ns - 1000ns)
*	Reading 01101010100110111001110101011100 from address 0000010 (from port 0) during cycle 200 (1000ns - 1005ns)
*	Reading 00101011011100100010010010110010 from address 0000011 (from port 0) during cycle 201 (1005ns - 1010ns)
*	Reading 11101100000111101010000011000011 from address 1111011 (from port 0) during cycle 202 (1010ns - 1015ns)
*	Writing 01001011100110000110000101111011  to  address 1111011 (from port 0) during cycle 203 (1015ns - 1020ns)
*	Writing 00101000010101010111001010111010  to  address 0000010 (from port 0) during cycle 204 (1020ns - 1025ns)
*	Idle during cycle 205 (1025ns - 1030ns)

* Generation of data and address signals
* (time, data): [(0, 0), (5, 0), (10, 1), (15, 1), (20, 1), (25, 1), (30, 0), (35, 1), (40, 1), (45, 1), (50, 1), (55, 1), (60, 1), (65, 1), (70, 0), (75, 0), (80, 0), (85, 0), (90, 0), (95, 0), (100, 1), (105, 1), (110, 1), (115, 0), (120, 0), (125, 1), (130, 1), (135, 1), (140, 0), (145, 1), (150, 1), (155, 1), (160, 1), (165, 1), (170, 1), (175, 1), (180, 1), (185, 1), (190, 1), (195, 1), (200, 1), (205, 1), (210, 1), (215, 1), (220, 1), (225, 1), (230, 1), (235, 1), (240, 1), (245, 1), (250, 1), (255, 1), (260, 1), (265, 1), (270, 0), (275, 0), (280, 0), (285, 1), (290, 1), (295, 1), (300, 1), (305, 0), (310, 0), (315, 0), (320, 0), (325, 0), (330, 0), (335, 0), (340, 0), (345, 1), (350, 1), (355, 1), (360, 1), (365, 1), (370, 0), (375, 1), (380, 1), (385, 0), (390, 0), (395, 0), (400, 0), (405, 0), (410, 0), (415, 1), (420, 0), (425, 0), (430, 1), (435, 1), (440, 1), (445, 1), (450, 1), (455, 1), (460, 1), (465, 1), (470, 1), (475, 1), (480, 1), (485, 1), (490, 1), (495, 1), (500, 1), (505, 1), (510, 1), (515, 1), (520, 1), (525, 1), (530, 1), (535, 0), (540, 1), (545, 1), (550, 1), (555, 0), (560, 0), (565, 0), (570, 0), (575, 0), (580, 0), (585, 1), (590, 1), (595, 1), (600, 1), (605, 1), (610, 1), (615, 1), (620, 0), (625, 0), (630, 0), (635, 0), (640, 0), (645, 0), (650, 1), (655, 1), (660, 1), (665, 1), (670, 1), (675, 1), (680, 1), (685, 1), (690, 0), (695, 0), (700, 0), (705, 0), (710, 0), (715, 0), (720, 0), (725, 0), (730, 0), (735, 0), (740, 0), (745, 0), (750, 0), (755, 0), (760, 0), (765, 0), (770, 0), (775, 0), (780, 0), (785, 0), (790, 0), (795, 1), (800, 1), (805, 1), (810, 1), (815, 1), (820, 1), (825, 1), (830, 1), (835, 1), (840, 0), (845, 0), (850, 0), (855, 0), (860, 0), (865, 0), (870, 1), (875, 1), (880, 1), (885, 1), (890, 1), (895, 0), (900, 0), (905, 0), (910, 0), (915, 0), (920, 0), (925, 0), (930, 0), (935, 0), (940, 0), (945, 0), (950, 0), (955, 0), (960, 0), (965, 0), (970, 0), (975, 0), (980, 0), (985, 1), (990, 1), (995, 1), (1000, 1), (1005, 1), (1010, 1), (1015, 1), (1020, 0), (1025, 0)]
Vdin0_0  din0_0  0 PWL (0n 0.0v 4.745n 0.0v 4.755n 0.0v 9.745n 0.0v 9.755n 1.1v 14.745n 1.1v 14.755n 1.1v 19.745n 1.1v 19.755n 1.1v 24.745n 1.1v 24.755n 1.1v 29.745n 1.1v 29.755n 0.0v 34.745n 0.0v 34.755n 1.1v 39.745n 1.1v 39.755n 1.1v 44.745n 1.1v 44.755n 1.1v 49.745n 1.1v 49.755n 1.1v 54.745n 1.1v 54.755n 1.1v 59.745n 1.1v 59.755n 1.1v 64.745n 1.1v 64.755n 1.1v 69.745n 1.1v 69.755n 0.0v 74.745n 0.0v 74.755n 0.0v 79.745n 0.0v 79.755n 0.0v 84.745n 0.0v 84.755n 0.0v 89.745n 0.0v 89.755n 0.0v 94.745n 0.0v 94.755n 0.0v 99.745n 0.0v 99.755n 1.1v 104.745n 1.1v 104.755n 1.1v 109.745n 1.1v 109.755n 1.1v 114.745n 1.1v 114.755n 0.0v 119.745n 0.0v 119.755n 0.0v 124.745n 0.0v 124.755n 1.1v 129.745n 1.1v 129.755n 1.1v 134.745n 1.1v 134.755n 1.1v 139.745n 1.1v 139.755n 0.0v 144.745n 0.0v 144.755n 1.1v 149.745n 1.1v 149.755n 1.1v 154.745n 1.1v 154.755n 1.1v 159.745n 1.1v 159.755n 1.1v 164.745n 1.1v 164.755n 1.1v 169.745n 1.1v 169.755n 1.1v 174.745n 1.1v 174.755n 1.1v 179.745n 1.1v 179.755n 1.1v 184.745n 1.1v 184.755n 1.1v 189.745n 1.1v 189.755n 1.1v 194.745n 1.1v 194.755n 1.1v 199.745n 1.1v 199.755n 1.1v 204.745n 1.1v 204.755n 1.1v 209.745n 1.1v 209.755n 1.1v 214.745n 1.1v 214.755n 1.1v 219.745n 1.1v 219.755n 1.1v 224.745n 1.1v 224.755n 1.1v 229.745n 1.1v 229.755n 1.1v 234.745n 1.1v 234.755n 1.1v 239.745n 1.1v 239.755n 1.1v 244.745n 1.1v 244.755n 1.1v 249.745n 1.1v 249.755n 1.1v 254.745n 1.1v 254.755n 1.1v 259.745n 1.1v 259.755n 1.1v 264.745n 1.1v 264.755n 1.1v 269.745n 1.1v 269.755n 0.0v 274.745n 0.0v 274.755n 0.0v 279.745n 0.0v 279.755n 0.0v 284.745n 0.0v 284.755n 1.1v 289.745n 1.1v 289.755n 1.1v 294.745n 1.1v 294.755n 1.1v 299.745n 1.1v 299.755n 1.1v 304.745n 1.1v 304.755n 0.0v 309.745n 0.0v 309.755n 0.0v 314.745n 0.0v 314.755n 0.0v 319.745n 0.0v 319.755n 0.0v 324.745n 0.0v 324.755n 0.0v 329.745n 0.0v 329.755n 0.0v 334.745n 0.0v 334.755n 0.0v 339.745n 0.0v 339.755n 0.0v 344.745n 0.0v 344.755n 1.1v 349.745n 1.1v 349.755n 1.1v 354.745n 1.1v 354.755n 1.1v 359.745n 1.1v 359.755n 1.1v 364.745n 1.1v 364.755n 1.1v 369.745n 1.1v 369.755n 0.0v 374.745n 0.0v 374.755n 1.1v 379.745n 1.1v 379.755n 1.1v 384.745n 1.1v 384.755n 0.0v 389.745n 0.0v 389.755n 0.0v 394.745n 0.0v 394.755n 0.0v 399.745n 0.0v 399.755n 0.0v 404.745n 0.0v 404.755n 0.0v 409.745n 0.0v 409.755n 0.0v 414.745n 0.0v 414.755n 1.1v 419.745n 1.1v 419.755n 0.0v 424.745n 0.0v 424.755n 0.0v 429.745n 0.0v 429.755n 1.1v 434.745n 1.1v 434.755n 1.1v 439.745n 1.1v 439.755n 1.1v 444.745n 1.1v 444.755n 1.1v 449.745n 1.1v 449.755n 1.1v 454.745n 1.1v 454.755n 1.1v 459.745n 1.1v 459.755n 1.1v 464.745n 1.1v 464.755n 1.1v 469.745n 1.1v 469.755n 1.1v 474.745n 1.1v 474.755n 1.1v 479.745n 1.1v 479.755n 1.1v 484.745n 1.1v 484.755n 1.1v 489.745n 1.1v 489.755n 1.1v 494.745n 1.1v 494.755n 1.1v 499.745n 1.1v 499.755n 1.1v 504.745n 1.1v 504.755n 1.1v 509.745n 1.1v 509.755n 1.1v 514.745n 1.1v 514.755n 1.1v 519.745n 1.1v 519.755n 1.1v 524.745n 1.1v 524.755n 1.1v 529.745n 1.1v 529.755n 1.1v 534.745n 1.1v 534.755n 0.0v 539.745n 0.0v 539.755n 1.1v 544.745n 1.1v 544.755n 1.1v 549.745n 1.1v 549.755n 1.1v 554.745n 1.1v 554.755n 0.0v 559.745n 0.0v 559.755n 0.0v 564.745n 0.0v 564.755n 0.0v 569.745n 0.0v 569.755n 0.0v 574.745n 0.0v 574.755n 0.0v 579.745n 0.0v 579.755n 0.0v 584.745n 0.0v 584.755n 1.1v 589.745n 1.1v 589.755n 1.1v 594.745n 1.1v 594.755n 1.1v 599.745n 1.1v 599.755n 1.1v 604.745n 1.1v 604.755n 1.1v 609.745n 1.1v 609.755n 1.1v 614.745n 1.1v 614.755n 1.1v 619.745n 1.1v 619.755n 0.0v 624.745n 0.0v 624.755n 0.0v 629.745n 0.0v 629.755n 0.0v 634.745n 0.0v 634.755n 0.0v 639.745n 0.0v 639.755n 0.0v 644.745n 0.0v 644.755n 0.0v 649.745n 0.0v 649.755n 1.1v 654.745n 1.1v 654.755n 1.1v 659.745n 1.1v 659.755n 1.1v 664.745n 1.1v 664.755n 1.1v 669.745n 1.1v 669.755n 1.1v 674.745n 1.1v 674.755n 1.1v 679.745n 1.1v 679.755n 1.1v 684.745n 1.1v 684.755n 1.1v 689.745n 1.1v 689.755n 0.0v 694.745n 0.0v 694.755n 0.0v 699.745n 0.0v 699.755n 0.0v 704.745n 0.0v 704.755n 0.0v 709.745n 0.0v 709.755n 0.0v 714.745n 0.0v 714.755n 0.0v 719.745n 0.0v 719.755n 0.0v 724.745n 0.0v 724.755n 0.0v 729.745n 0.0v 729.755n 0.0v 734.745n 0.0v 734.755n 0.0v 739.745n 0.0v 739.755n 0.0v 744.745n 0.0v 744.755n 0.0v 749.745n 0.0v 749.755n 0.0v 754.745n 0.0v 754.755n 0.0v 759.745n 0.0v 759.755n 0.0v 764.745n 0.0v 764.755n 0.0v 769.745n 0.0v 769.755n 0.0v 774.745n 0.0v 774.755n 0.0v 779.745n 0.0v 779.755n 0.0v 784.745n 0.0v 784.755n 0.0v 789.745n 0.0v 789.755n 0.0v 794.745n 0.0v 794.755n 1.1v 799.745n 1.1v 799.755n 1.1v 804.745n 1.1v 804.755n 1.1v 809.745n 1.1v 809.755n 1.1v 814.745n 1.1v 814.755n 1.1v 819.745n 1.1v 819.755n 1.1v 824.745n 1.1v 824.755n 1.1v 829.745n 1.1v 829.755n 1.1v 834.745n 1.1v 834.755n 1.1v 839.745n 1.1v 839.755n 0.0v 844.745n 0.0v 844.755n 0.0v 849.745n 0.0v 849.755n 0.0v 854.745n 0.0v 854.755n 0.0v 859.745n 0.0v 859.755n 0.0v 864.745n 0.0v 864.755n 0.0v 869.745n 0.0v 869.755n 1.1v 874.745n 1.1v 874.755n 1.1v 879.745n 1.1v 879.755n 1.1v 884.745n 1.1v 884.755n 1.1v 889.745n 1.1v 889.755n 1.1v 894.745n 1.1v 894.755n 0.0v 899.745n 0.0v 899.755n 0.0v 904.745n 0.0v 904.755n 0.0v 909.745n 0.0v 909.755n 0.0v 914.745n 0.0v 914.755n 0.0v 919.745n 0.0v 919.755n 0.0v 924.745n 0.0v 924.755n 0.0v 929.745n 0.0v 929.755n 0.0v 934.745n 0.0v 934.755n 0.0v 939.745n 0.0v 939.755n 0.0v 944.745n 0.0v 944.755n 0.0v 949.745n 0.0v 949.755n 0.0v 954.745n 0.0v 954.755n 0.0v 959.745n 0.0v 959.755n 0.0v 964.745n 0.0v 964.755n 0.0v 969.745n 0.0v 969.755n 0.0v 974.745n 0.0v 974.755n 0.0v 979.745n 0.0v 979.755n 0.0v 984.745n 0.0v 984.755n 1.1v 989.745n 1.1v 989.755n 1.1v 994.745n 1.1v 994.755n 1.1v 999.745n 1.1v 999.755n 1.1v 1004.745n 1.1v 1004.755n 1.1v 1009.745n 1.1v 1009.755n 1.1v 1014.745n 1.1v 1014.755n 1.1v 1019.745n 1.1v 1019.755n 0.0v 1024.745n 0.0v 1024.755n 0.0v )
* (time, data): [(0, 0), (5, 1), (10, 1), (15, 1), (20, 1), (25, 1), (30, 1), (35, 0), (40, 0), (45, 0), (50, 0), (55, 0), (60, 1), (65, 1), (70, 0), (75, 0), (80, 0), (85, 0), (90, 0), (95, 0), (100, 1), (105, 1), (110, 1), (115, 1), (120, 1), (125, 0), (130, 0), (135, 1), (140, 1), (145, 0), (150, 0), (155, 0), (160, 0), (165, 0), (170, 0), (175, 0), (180, 0), (185, 0), (190, 0), (195, 0), (200, 0), (205, 0), (210, 0), (215, 0), (220, 0), (225, 0), (230, 0), (235, 0), (240, 0), (245, 0), (250, 0), (255, 1), (260, 1), (265, 1), (270, 0), (275, 0), (280, 0), (285, 0), (290, 0), (295, 0), (300, 0), (305, 1), (310, 1), (315, 1), (320, 1), (325, 1), (330, 1), (335, 1), (340, 1), (345, 0), (350, 0), (355, 0), (360, 0), (365, 0), (370, 0), (375, 0), (380, 0), (385, 1), (390, 1), (395, 1), (400, 1), (405, 1), (410, 1), (415, 1), (420, 0), (425, 0), (430, 0), (435, 0), (440, 0), (445, 0), (450, 0), (455, 0), (460, 0), (465, 0), (470, 0), (475, 0), (480, 0), (485, 0), (490, 0), (495, 0), (500, 0), (505, 0), (510, 0), (515, 0), (520, 0), (525, 0), (530, 0), (535, 1), (540, 1), (545, 1), (550, 1), (555, 1), (560, 1), (565, 1), (570, 0), (575, 0), (580, 0), (585, 0), (590, 0), (595, 0), (600, 0), (605, 0), (610, 0), (615, 0), (620, 0), (625, 0), (630, 0), (635, 0), (640, 0), (645, 0), (650, 1), (655, 1), (660, 1), (665, 1), (670, 1), (675, 1), (680, 1), (685, 1), (690, 1), (695, 1), (700, 1), (705, 1), (710, 1), (715, 0), (720, 0), (725, 0), (730, 0), (735, 0), (740, 0), (745, 0), (750, 0), (755, 0), (760, 0), (765, 0), (770, 0), (775, 0), (780, 0), (785, 0), (790, 0), (795, 1), (800, 1), (805, 1), (810, 1), (815, 1), (820, 1), (825, 1), (830, 1), (835, 1), (840, 0), (845, 0), (850, 0), (855, 0), (860, 0), (865, 0), (870, 1), (875, 1), (880, 1), (885, 1), (890, 1), (895, 1), (900, 1), (905, 1), (910, 1), (915, 1), (920, 0), (925, 0), (930, 0), (935, 0), (940, 0), (945, 0), (950, 0), (955, 0), (960, 0), (965, 0), (970, 0), (975, 0), (980, 0), (985, 1), (990, 1), (995, 1), (1000, 1), (1005, 1), (1010, 1), (1015, 1), (1020, 1), (1025, 1)]
Vdin0_1  din0_1  0 PWL (0n 0.0v 4.745n 0.0v 4.755n 1.1v 9.745n 1.1v 9.755n 1.1v 14.745n 1.1v 14.755n 1.1v 19.745n 1.1v 19.755n 1.1v 24.745n 1.1v 24.755n 1.1v 29.745n 1.1v 29.755n 1.1v 34.745n 1.1v 34.755n 0.0v 39.745n 0.0v 39.755n 0.0v 44.745n 0.0v 44.755n 0.0v 49.745n 0.0v 49.755n 0.0v 54.745n 0.0v 54.755n 0.0v 59.745n 0.0v 59.755n 1.1v 64.745n 1.1v 64.755n 1.1v 69.745n 1.1v 69.755n 0.0v 74.745n 0.0v 74.755n 0.0v 79.745n 0.0v 79.755n 0.0v 84.745n 0.0v 84.755n 0.0v 89.745n 0.0v 89.755n 0.0v 94.745n 0.0v 94.755n 0.0v 99.745n 0.0v 99.755n 1.1v 104.745n 1.1v 104.755n 1.1v 109.745n 1.1v 109.755n 1.1v 114.745n 1.1v 114.755n 1.1v 119.745n 1.1v 119.755n 1.1v 124.745n 1.1v 124.755n 0.0v 129.745n 0.0v 129.755n 0.0v 134.745n 0.0v 134.755n 1.1v 139.745n 1.1v 139.755n 1.1v 144.745n 1.1v 144.755n 0.0v 149.745n 0.0v 149.755n 0.0v 154.745n 0.0v 154.755n 0.0v 159.745n 0.0v 159.755n 0.0v 164.745n 0.0v 164.755n 0.0v 169.745n 0.0v 169.755n 0.0v 174.745n 0.0v 174.755n 0.0v 179.745n 0.0v 179.755n 0.0v 184.745n 0.0v 184.755n 0.0v 189.745n 0.0v 189.755n 0.0v 194.745n 0.0v 194.755n 0.0v 199.745n 0.0v 199.755n 0.0v 204.745n 0.0v 204.755n 0.0v 209.745n 0.0v 209.755n 0.0v 214.745n 0.0v 214.755n 0.0v 219.745n 0.0v 219.755n 0.0v 224.745n 0.0v 224.755n 0.0v 229.745n 0.0v 229.755n 0.0v 234.745n 0.0v 234.755n 0.0v 239.745n 0.0v 239.755n 0.0v 244.745n 0.0v 244.755n 0.0v 249.745n 0.0v 249.755n 0.0v 254.745n 0.0v 254.755n 1.1v 259.745n 1.1v 259.755n 1.1v 264.745n 1.1v 264.755n 1.1v 269.745n 1.1v 269.755n 0.0v 274.745n 0.0v 274.755n 0.0v 279.745n 0.0v 279.755n 0.0v 284.745n 0.0v 284.755n 0.0v 289.745n 0.0v 289.755n 0.0v 294.745n 0.0v 294.755n 0.0v 299.745n 0.0v 299.755n 0.0v 304.745n 0.0v 304.755n 1.1v 309.745n 1.1v 309.755n 1.1v 314.745n 1.1v 314.755n 1.1v 319.745n 1.1v 319.755n 1.1v 324.745n 1.1v 324.755n 1.1v 329.745n 1.1v 329.755n 1.1v 334.745n 1.1v 334.755n 1.1v 339.745n 1.1v 339.755n 1.1v 344.745n 1.1v 344.755n 0.0v 349.745n 0.0v 349.755n 0.0v 354.745n 0.0v 354.755n 0.0v 359.745n 0.0v 359.755n 0.0v 364.745n 0.0v 364.755n 0.0v 369.745n 0.0v 369.755n 0.0v 374.745n 0.0v 374.755n 0.0v 379.745n 0.0v 379.755n 0.0v 384.745n 0.0v 384.755n 1.1v 389.745n 1.1v 389.755n 1.1v 394.745n 1.1v 394.755n 1.1v 399.745n 1.1v 399.755n 1.1v 404.745n 1.1v 404.755n 1.1v 409.745n 1.1v 409.755n 1.1v 414.745n 1.1v 414.755n 1.1v 419.745n 1.1v 419.755n 0.0v 424.745n 0.0v 424.755n 0.0v 429.745n 0.0v 429.755n 0.0v 434.745n 0.0v 434.755n 0.0v 439.745n 0.0v 439.755n 0.0v 444.745n 0.0v 444.755n 0.0v 449.745n 0.0v 449.755n 0.0v 454.745n 0.0v 454.755n 0.0v 459.745n 0.0v 459.755n 0.0v 464.745n 0.0v 464.755n 0.0v 469.745n 0.0v 469.755n 0.0v 474.745n 0.0v 474.755n 0.0v 479.745n 0.0v 479.755n 0.0v 484.745n 0.0v 484.755n 0.0v 489.745n 0.0v 489.755n 0.0v 494.745n 0.0v 494.755n 0.0v 499.745n 0.0v 499.755n 0.0v 504.745n 0.0v 504.755n 0.0v 509.745n 0.0v 509.755n 0.0v 514.745n 0.0v 514.755n 0.0v 519.745n 0.0v 519.755n 0.0v 524.745n 0.0v 524.755n 0.0v 529.745n 0.0v 529.755n 0.0v 534.745n 0.0v 534.755n 1.1v 539.745n 1.1v 539.755n 1.1v 544.745n 1.1v 544.755n 1.1v 549.745n 1.1v 549.755n 1.1v 554.745n 1.1v 554.755n 1.1v 559.745n 1.1v 559.755n 1.1v 564.745n 1.1v 564.755n 1.1v 569.745n 1.1v 569.755n 0.0v 574.745n 0.0v 574.755n 0.0v 579.745n 0.0v 579.755n 0.0v 584.745n 0.0v 584.755n 0.0v 589.745n 0.0v 589.755n 0.0v 594.745n 0.0v 594.755n 0.0v 599.745n 0.0v 599.755n 0.0v 604.745n 0.0v 604.755n 0.0v 609.745n 0.0v 609.755n 0.0v 614.745n 0.0v 614.755n 0.0v 619.745n 0.0v 619.755n 0.0v 624.745n 0.0v 624.755n 0.0v 629.745n 0.0v 629.755n 0.0v 634.745n 0.0v 634.755n 0.0v 639.745n 0.0v 639.755n 0.0v 644.745n 0.0v 644.755n 0.0v 649.745n 0.0v 649.755n 1.1v 654.745n 1.1v 654.755n 1.1v 659.745n 1.1v 659.755n 1.1v 664.745n 1.1v 664.755n 1.1v 669.745n 1.1v 669.755n 1.1v 674.745n 1.1v 674.755n 1.1v 679.745n 1.1v 679.755n 1.1v 684.745n 1.1v 684.755n 1.1v 689.745n 1.1v 689.755n 1.1v 694.745n 1.1v 694.755n 1.1v 699.745n 1.1v 699.755n 1.1v 704.745n 1.1v 704.755n 1.1v 709.745n 1.1v 709.755n 1.1v 714.745n 1.1v 714.755n 0.0v 719.745n 0.0v 719.755n 0.0v 724.745n 0.0v 724.755n 0.0v 729.745n 0.0v 729.755n 0.0v 734.745n 0.0v 734.755n 0.0v 739.745n 0.0v 739.755n 0.0v 744.745n 0.0v 744.755n 0.0v 749.745n 0.0v 749.755n 0.0v 754.745n 0.0v 754.755n 0.0v 759.745n 0.0v 759.755n 0.0v 764.745n 0.0v 764.755n 0.0v 769.745n 0.0v 769.755n 0.0v 774.745n 0.0v 774.755n 0.0v 779.745n 0.0v 779.755n 0.0v 784.745n 0.0v 784.755n 0.0v 789.745n 0.0v 789.755n 0.0v 794.745n 0.0v 794.755n 1.1v 799.745n 1.1v 799.755n 1.1v 804.745n 1.1v 804.755n 1.1v 809.745n 1.1v 809.755n 1.1v 814.745n 1.1v 814.755n 1.1v 819.745n 1.1v 819.755n 1.1v 824.745n 1.1v 824.755n 1.1v 829.745n 1.1v 829.755n 1.1v 834.745n 1.1v 834.755n 1.1v 839.745n 1.1v 839.755n 0.0v 844.745n 0.0v 844.755n 0.0v 849.745n 0.0v 849.755n 0.0v 854.745n 0.0v 854.755n 0.0v 859.745n 0.0v 859.755n 0.0v 864.745n 0.0v 864.755n 0.0v 869.745n 0.0v 869.755n 1.1v 874.745n 1.1v 874.755n 1.1v 879.745n 1.1v 879.755n 1.1v 884.745n 1.1v 884.755n 1.1v 889.745n 1.1v 889.755n 1.1v 894.745n 1.1v 894.755n 1.1v 899.745n 1.1v 899.755n 1.1v 904.745n 1.1v 904.755n 1.1v 909.745n 1.1v 909.755n 1.1v 914.745n 1.1v 914.755n 1.1v 919.745n 1.1v 919.755n 0.0v 924.745n 0.0v 924.755n 0.0v 929.745n 0.0v 929.755n 0.0v 934.745n 0.0v 934.755n 0.0v 939.745n 0.0v 939.755n 0.0v 944.745n 0.0v 944.755n 0.0v 949.745n 0.0v 949.755n 0.0v 954.745n 0.0v 954.755n 0.0v 959.745n 0.0v 959.755n 0.0v 964.745n 0.0v 964.755n 0.0v 969.745n 0.0v 969.755n 0.0v 974.745n 0.0v 974.755n 0.0v 979.745n 0.0v 979.755n 0.0v 984.745n 0.0v 984.755n 1.1v 989.745n 1.1v 989.755n 1.1v 994.745n 1.1v 994.755n 1.1v 999.745n 1.1v 999.755n 1.1v 1004.745n 1.1v 1004.755n 1.1v 1009.745n 1.1v 1009.755n 1.1v 1014.745n 1.1v 1014.755n 1.1v 1019.745n 1.1v 1019.755n 1.1v 1024.745n 1.1v 1024.755n 1.1v )
* (time, data): [(0, 0), (5, 1), (10, 0), (15, 0), (20, 0), (25, 0), (30, 0), (35, 1), (40, 0), (45, 0), (50, 0), (55, 0), (60, 1), (65, 1), (70, 0), (75, 0), (80, 0), (85, 0), (90, 0), (95, 0), (100, 1), (105, 1), (110, 1), (115, 0), (120, 0), (125, 1), (130, 1), (135, 1), (140, 1), (145, 1), (150, 1), (155, 1), (160, 1), (165, 0), (170, 0), (175, 0), (180, 0), (185, 0), (190, 0), (195, 0), (200, 1), (205, 1), (210, 1), (215, 1), (220, 0), (225, 0), (230, 0), (235, 0), (240, 0), (245, 1), (250, 1), (255, 0), (260, 0), (265, 0), (270, 0), (275, 0), (280, 0), (285, 1), (290, 1), (295, 1), (300, 1), (305, 1), (310, 1), (315, 1), (320, 1), (325, 0), (330, 1), (335, 1), (340, 1), (345, 1), (350, 1), (355, 1), (360, 1), (365, 1), (370, 0), (375, 1), (380, 1), (385, 0), (390, 0), (395, 0), (400, 0), (405, 0), (410, 0), (415, 1), (420, 0), (425, 0), (430, 1), (435, 1), (440, 1), (445, 1), (450, 1), (455, 1), (460, 1), (465, 1), (470, 1), (475, 1), (480, 1), (485, 1), (490, 1), (495, 0), (500, 0), (505, 0), (510, 0), (515, 0), (520, 1), (525, 1), (530, 1), (535, 1), (540, 1), (545, 1), (550, 1), (555, 1), (560, 1), (565, 1), (570, 0), (575, 0), (580, 0), (585, 0), (590, 0), (595, 0), (600, 1), (605, 1), (610, 1), (615, 1), (620, 1), (625, 1), (630, 1), (635, 1), (640, 1), (645, 1), (650, 1), (655, 1), (660, 1), (665, 1), (670, 1), (675, 1), (680, 1), (685, 1), (690, 0), (695, 0), (700, 0), (705, 0), (710, 0), (715, 1), (720, 1), (725, 0), (730, 0), (735, 0), (740, 0), (745, 0), (750, 0), (755, 0), (760, 0), (765, 0), (770, 0), (775, 0), (780, 0), (785, 0), (790, 0), (795, 0), (800, 0), (805, 0), (810, 0), (815, 0), (820, 0), (825, 0), (830, 0), (835, 0), (840, 1), (845, 1), (850, 1), (855, 1), (860, 1), (865, 1), (870, 1), (875, 1), (880, 1), (885, 1), (890, 1), (895, 0), (900, 0), (905, 0), (910, 0), (915, 0), (920, 1), (925, 1), (930, 1), (935, 1), (940, 1), (945, 1), (950, 1), (955, 1), (960, 1), (965, 1), (970, 1), (975, 1), (980, 1), (985, 1), (990, 0), (995, 0), (1000, 0), (1005, 0), (1010, 0), (1015, 0), (1020, 0), (1025, 0)]
Vdin0_2  din0_2  0 PWL (0n 0.0v 4.745n 0.0v 4.755n 1.1v 9.745n 1.1v 9.755n 0.0v 14.745n 0.0v 14.755n 0.0v 19.745n 0.0v 19.755n 0.0v 24.745n 0.0v 24.755n 0.0v 29.745n 0.0v 29.755n 0.0v 34.745n 0.0v 34.755n 1.1v 39.745n 1.1v 39.755n 0.0v 44.745n 0.0v 44.755n 0.0v 49.745n 0.0v 49.755n 0.0v 54.745n 0.0v 54.755n 0.0v 59.745n 0.0v 59.755n 1.1v 64.745n 1.1v 64.755n 1.1v 69.745n 1.1v 69.755n 0.0v 74.745n 0.0v 74.755n 0.0v 79.745n 0.0v 79.755n 0.0v 84.745n 0.0v 84.755n 0.0v 89.745n 0.0v 89.755n 0.0v 94.745n 0.0v 94.755n 0.0v 99.745n 0.0v 99.755n 1.1v 104.745n 1.1v 104.755n 1.1v 109.745n 1.1v 109.755n 1.1v 114.745n 1.1v 114.755n 0.0v 119.745n 0.0v 119.755n 0.0v 124.745n 0.0v 124.755n 1.1v 129.745n 1.1v 129.755n 1.1v 134.745n 1.1v 134.755n 1.1v 139.745n 1.1v 139.755n 1.1v 144.745n 1.1v 144.755n 1.1v 149.745n 1.1v 149.755n 1.1v 154.745n 1.1v 154.755n 1.1v 159.745n 1.1v 159.755n 1.1v 164.745n 1.1v 164.755n 0.0v 169.745n 0.0v 169.755n 0.0v 174.745n 0.0v 174.755n 0.0v 179.745n 0.0v 179.755n 0.0v 184.745n 0.0v 184.755n 0.0v 189.745n 0.0v 189.755n 0.0v 194.745n 0.0v 194.755n 0.0v 199.745n 0.0v 199.755n 1.1v 204.745n 1.1v 204.755n 1.1v 209.745n 1.1v 209.755n 1.1v 214.745n 1.1v 214.755n 1.1v 219.745n 1.1v 219.755n 0.0v 224.745n 0.0v 224.755n 0.0v 229.745n 0.0v 229.755n 0.0v 234.745n 0.0v 234.755n 0.0v 239.745n 0.0v 239.755n 0.0v 244.745n 0.0v 244.755n 1.1v 249.745n 1.1v 249.755n 1.1v 254.745n 1.1v 254.755n 0.0v 259.745n 0.0v 259.755n 0.0v 264.745n 0.0v 264.755n 0.0v 269.745n 0.0v 269.755n 0.0v 274.745n 0.0v 274.755n 0.0v 279.745n 0.0v 279.755n 0.0v 284.745n 0.0v 284.755n 1.1v 289.745n 1.1v 289.755n 1.1v 294.745n 1.1v 294.755n 1.1v 299.745n 1.1v 299.755n 1.1v 304.745n 1.1v 304.755n 1.1v 309.745n 1.1v 309.755n 1.1v 314.745n 1.1v 314.755n 1.1v 319.745n 1.1v 319.755n 1.1v 324.745n 1.1v 324.755n 0.0v 329.745n 0.0v 329.755n 1.1v 334.745n 1.1v 334.755n 1.1v 339.745n 1.1v 339.755n 1.1v 344.745n 1.1v 344.755n 1.1v 349.745n 1.1v 349.755n 1.1v 354.745n 1.1v 354.755n 1.1v 359.745n 1.1v 359.755n 1.1v 364.745n 1.1v 364.755n 1.1v 369.745n 1.1v 369.755n 0.0v 374.745n 0.0v 374.755n 1.1v 379.745n 1.1v 379.755n 1.1v 384.745n 1.1v 384.755n 0.0v 389.745n 0.0v 389.755n 0.0v 394.745n 0.0v 394.755n 0.0v 399.745n 0.0v 399.755n 0.0v 404.745n 0.0v 404.755n 0.0v 409.745n 0.0v 409.755n 0.0v 414.745n 0.0v 414.755n 1.1v 419.745n 1.1v 419.755n 0.0v 424.745n 0.0v 424.755n 0.0v 429.745n 0.0v 429.755n 1.1v 434.745n 1.1v 434.755n 1.1v 439.745n 1.1v 439.755n 1.1v 444.745n 1.1v 444.755n 1.1v 449.745n 1.1v 449.755n 1.1v 454.745n 1.1v 454.755n 1.1v 459.745n 1.1v 459.755n 1.1v 464.745n 1.1v 464.755n 1.1v 469.745n 1.1v 469.755n 1.1v 474.745n 1.1v 474.755n 1.1v 479.745n 1.1v 479.755n 1.1v 484.745n 1.1v 484.755n 1.1v 489.745n 1.1v 489.755n 1.1v 494.745n 1.1v 494.755n 0.0v 499.745n 0.0v 499.755n 0.0v 504.745n 0.0v 504.755n 0.0v 509.745n 0.0v 509.755n 0.0v 514.745n 0.0v 514.755n 0.0v 519.745n 0.0v 519.755n 1.1v 524.745n 1.1v 524.755n 1.1v 529.745n 1.1v 529.755n 1.1v 534.745n 1.1v 534.755n 1.1v 539.745n 1.1v 539.755n 1.1v 544.745n 1.1v 544.755n 1.1v 549.745n 1.1v 549.755n 1.1v 554.745n 1.1v 554.755n 1.1v 559.745n 1.1v 559.755n 1.1v 564.745n 1.1v 564.755n 1.1v 569.745n 1.1v 569.755n 0.0v 574.745n 0.0v 574.755n 0.0v 579.745n 0.0v 579.755n 0.0v 584.745n 0.0v 584.755n 0.0v 589.745n 0.0v 589.755n 0.0v 594.745n 0.0v 594.755n 0.0v 599.745n 0.0v 599.755n 1.1v 604.745n 1.1v 604.755n 1.1v 609.745n 1.1v 609.755n 1.1v 614.745n 1.1v 614.755n 1.1v 619.745n 1.1v 619.755n 1.1v 624.745n 1.1v 624.755n 1.1v 629.745n 1.1v 629.755n 1.1v 634.745n 1.1v 634.755n 1.1v 639.745n 1.1v 639.755n 1.1v 644.745n 1.1v 644.755n 1.1v 649.745n 1.1v 649.755n 1.1v 654.745n 1.1v 654.755n 1.1v 659.745n 1.1v 659.755n 1.1v 664.745n 1.1v 664.755n 1.1v 669.745n 1.1v 669.755n 1.1v 674.745n 1.1v 674.755n 1.1v 679.745n 1.1v 679.755n 1.1v 684.745n 1.1v 684.755n 1.1v 689.745n 1.1v 689.755n 0.0v 694.745n 0.0v 694.755n 0.0v 699.745n 0.0v 699.755n 0.0v 704.745n 0.0v 704.755n 0.0v 709.745n 0.0v 709.755n 0.0v 714.745n 0.0v 714.755n 1.1v 719.745n 1.1v 719.755n 1.1v 724.745n 1.1v 724.755n 0.0v 729.745n 0.0v 729.755n 0.0v 734.745n 0.0v 734.755n 0.0v 739.745n 0.0v 739.755n 0.0v 744.745n 0.0v 744.755n 0.0v 749.745n 0.0v 749.755n 0.0v 754.745n 0.0v 754.755n 0.0v 759.745n 0.0v 759.755n 0.0v 764.745n 0.0v 764.755n 0.0v 769.745n 0.0v 769.755n 0.0v 774.745n 0.0v 774.755n 0.0v 779.745n 0.0v 779.755n 0.0v 784.745n 0.0v 784.755n 0.0v 789.745n 0.0v 789.755n 0.0v 794.745n 0.0v 794.755n 0.0v 799.745n 0.0v 799.755n 0.0v 804.745n 0.0v 804.755n 0.0v 809.745n 0.0v 809.755n 0.0v 814.745n 0.0v 814.755n 0.0v 819.745n 0.0v 819.755n 0.0v 824.745n 0.0v 824.755n 0.0v 829.745n 0.0v 829.755n 0.0v 834.745n 0.0v 834.755n 0.0v 839.745n 0.0v 839.755n 1.1v 844.745n 1.1v 844.755n 1.1v 849.745n 1.1v 849.755n 1.1v 854.745n 1.1v 854.755n 1.1v 859.745n 1.1v 859.755n 1.1v 864.745n 1.1v 864.755n 1.1v 869.745n 1.1v 869.755n 1.1v 874.745n 1.1v 874.755n 1.1v 879.745n 1.1v 879.755n 1.1v 884.745n 1.1v 884.755n 1.1v 889.745n 1.1v 889.755n 1.1v 894.745n 1.1v 894.755n 0.0v 899.745n 0.0v 899.755n 0.0v 904.745n 0.0v 904.755n 0.0v 909.745n 0.0v 909.755n 0.0v 914.745n 0.0v 914.755n 0.0v 919.745n 0.0v 919.755n 1.1v 924.745n 1.1v 924.755n 1.1v 929.745n 1.1v 929.755n 1.1v 934.745n 1.1v 934.755n 1.1v 939.745n 1.1v 939.755n 1.1v 944.745n 1.1v 944.755n 1.1v 949.745n 1.1v 949.755n 1.1v 954.745n 1.1v 954.755n 1.1v 959.745n 1.1v 959.755n 1.1v 964.745n 1.1v 964.755n 1.1v 969.745n 1.1v 969.755n 1.1v 974.745n 1.1v 974.755n 1.1v 979.745n 1.1v 979.755n 1.1v 984.745n 1.1v 984.755n 1.1v 989.745n 1.1v 989.755n 0.0v 994.745n 0.0v 994.755n 0.0v 999.745n 0.0v 999.755n 0.0v 1004.745n 0.0v 1004.755n 0.0v 1009.745n 0.0v 1009.755n 0.0v 1014.745n 0.0v 1014.755n 0.0v 1019.745n 0.0v 1019.755n 0.0v 1024.745n 0.0v 1024.755n 0.0v )
* (time, data): [(0, 0), (5, 1), (10, 1), (15, 1), (20, 1), (25, 1), (30, 1), (35, 1), (40, 0), (45, 0), (50, 0), (55, 0), (60, 1), (65, 1), (70, 0), (75, 0), (80, 0), (85, 0), (90, 0), (95, 0), (100, 0), (105, 0), (110, 0), (115, 1), (120, 1), (125, 1), (130, 1), (135, 1), (140, 1), (145, 0), (150, 0), (155, 0), (160, 0), (165, 1), (170, 1), (175, 1), (180, 1), (185, 1), (190, 1), (195, 1), (200, 0), (205, 0), (210, 0), (215, 0), (220, 1), (225, 1), (230, 0), (235, 0), (240, 0), (245, 0), (250, 0), (255, 0), (260, 0), (265, 0), (270, 1), (275, 1), (280, 1), (285, 0), (290, 0), (295, 0), (300, 0), (305, 0), (310, 0), (315, 0), (320, 0), (325, 0), (330, 1), (335, 1), (340, 1), (345, 1), (350, 1), (355, 1), (360, 1), (365, 1), (370, 0), (375, 0), (380, 0), (385, 0), (390, 0), (395, 0), (400, 0), (405, 0), (410, 0), (415, 1), (420, 1), (425, 1), (430, 0), (435, 0), (440, 0), (445, 0), (450, 0), (455, 0), (460, 0), (465, 0), (470, 0), (475, 0), (480, 0), (485, 1), (490, 1), (495, 1), (500, 1), (505, 1), (510, 1), (515, 1), (520, 0), (525, 0), (530, 0), (535, 0), (540, 1), (545, 1), (550, 1), (555, 1), (560, 1), (565, 1), (570, 1), (575, 1), (580, 1), (585, 1), (590, 1), (595, 1), (600, 1), (605, 1), (610, 1), (615, 1), (620, 0), (625, 0), (630, 0), (635, 0), (640, 0), (645, 0), (650, 0), (655, 0), (660, 0), (665, 0), (670, 0), (675, 0), (680, 0), (685, 0), (690, 0), (695, 0), (700, 0), (705, 0), (710, 0), (715, 0), (720, 0), (725, 1), (730, 1), (735, 1), (740, 1), (745, 1), (750, 1), (755, 1), (760, 1), (765, 1), (770, 1), (775, 1), (780, 1), (785, 1), (790, 1), (795, 1), (800, 1), (805, 1), (810, 1), (815, 1), (820, 1), (825, 1), (830, 1), (835, 1), (840, 1), (845, 1), (850, 1), (855, 1), (860, 1), (865, 1), (870, 1), (875, 1), (880, 1), (885, 1), (890, 1), (895, 0), (900, 0), (905, 0), (910, 0), (915, 0), (920, 0), (925, 0), (930, 0), (935, 0), (940, 1), (945, 1), (950, 1), (955, 1), (960, 1), (965, 1), (970, 1), (975, 1), (980, 1), (985, 1), (990, 0), (995, 0), (1000, 0), (1005, 0), (1010, 0), (1015, 1), (1020, 1), (1025, 1)]
Vdin0_3  din0_3  0 PWL (0n 0.0v 4.745n 0.0v 4.755n 1.1v 9.745n 1.1v 9.755n 1.1v 14.745n 1.1v 14.755n 1.1v 19.745n 1.1v 19.755n 1.1v 24.745n 1.1v 24.755n 1.1v 29.745n 1.1v 29.755n 1.1v 34.745n 1.1v 34.755n 1.1v 39.745n 1.1v 39.755n 0.0v 44.745n 0.0v 44.755n 0.0v 49.745n 0.0v 49.755n 0.0v 54.745n 0.0v 54.755n 0.0v 59.745n 0.0v 59.755n 1.1v 64.745n 1.1v 64.755n 1.1v 69.745n 1.1v 69.755n 0.0v 74.745n 0.0v 74.755n 0.0v 79.745n 0.0v 79.755n 0.0v 84.745n 0.0v 84.755n 0.0v 89.745n 0.0v 89.755n 0.0v 94.745n 0.0v 94.755n 0.0v 99.745n 0.0v 99.755n 0.0v 104.745n 0.0v 104.755n 0.0v 109.745n 0.0v 109.755n 0.0v 114.745n 0.0v 114.755n 1.1v 119.745n 1.1v 119.755n 1.1v 124.745n 1.1v 124.755n 1.1v 129.745n 1.1v 129.755n 1.1v 134.745n 1.1v 134.755n 1.1v 139.745n 1.1v 139.755n 1.1v 144.745n 1.1v 144.755n 0.0v 149.745n 0.0v 149.755n 0.0v 154.745n 0.0v 154.755n 0.0v 159.745n 0.0v 159.755n 0.0v 164.745n 0.0v 164.755n 1.1v 169.745n 1.1v 169.755n 1.1v 174.745n 1.1v 174.755n 1.1v 179.745n 1.1v 179.755n 1.1v 184.745n 1.1v 184.755n 1.1v 189.745n 1.1v 189.755n 1.1v 194.745n 1.1v 194.755n 1.1v 199.745n 1.1v 199.755n 0.0v 204.745n 0.0v 204.755n 0.0v 209.745n 0.0v 209.755n 0.0v 214.745n 0.0v 214.755n 0.0v 219.745n 0.0v 219.755n 1.1v 224.745n 1.1v 224.755n 1.1v 229.745n 1.1v 229.755n 0.0v 234.745n 0.0v 234.755n 0.0v 239.745n 0.0v 239.755n 0.0v 244.745n 0.0v 244.755n 0.0v 249.745n 0.0v 249.755n 0.0v 254.745n 0.0v 254.755n 0.0v 259.745n 0.0v 259.755n 0.0v 264.745n 0.0v 264.755n 0.0v 269.745n 0.0v 269.755n 1.1v 274.745n 1.1v 274.755n 1.1v 279.745n 1.1v 279.755n 1.1v 284.745n 1.1v 284.755n 0.0v 289.745n 0.0v 289.755n 0.0v 294.745n 0.0v 294.755n 0.0v 299.745n 0.0v 299.755n 0.0v 304.745n 0.0v 304.755n 0.0v 309.745n 0.0v 309.755n 0.0v 314.745n 0.0v 314.755n 0.0v 319.745n 0.0v 319.755n 0.0v 324.745n 0.0v 324.755n 0.0v 329.745n 0.0v 329.755n 1.1v 334.745n 1.1v 334.755n 1.1v 339.745n 1.1v 339.755n 1.1v 344.745n 1.1v 344.755n 1.1v 349.745n 1.1v 349.755n 1.1v 354.745n 1.1v 354.755n 1.1v 359.745n 1.1v 359.755n 1.1v 364.745n 1.1v 364.755n 1.1v 369.745n 1.1v 369.755n 0.0v 374.745n 0.0v 374.755n 0.0v 379.745n 0.0v 379.755n 0.0v 384.745n 0.0v 384.755n 0.0v 389.745n 0.0v 389.755n 0.0v 394.745n 0.0v 394.755n 0.0v 399.745n 0.0v 399.755n 0.0v 404.745n 0.0v 404.755n 0.0v 409.745n 0.0v 409.755n 0.0v 414.745n 0.0v 414.755n 1.1v 419.745n 1.1v 419.755n 1.1v 424.745n 1.1v 424.755n 1.1v 429.745n 1.1v 429.755n 0.0v 434.745n 0.0v 434.755n 0.0v 439.745n 0.0v 439.755n 0.0v 444.745n 0.0v 444.755n 0.0v 449.745n 0.0v 449.755n 0.0v 454.745n 0.0v 454.755n 0.0v 459.745n 0.0v 459.755n 0.0v 464.745n 0.0v 464.755n 0.0v 469.745n 0.0v 469.755n 0.0v 474.745n 0.0v 474.755n 0.0v 479.745n 0.0v 479.755n 0.0v 484.745n 0.0v 484.755n 1.1v 489.745n 1.1v 489.755n 1.1v 494.745n 1.1v 494.755n 1.1v 499.745n 1.1v 499.755n 1.1v 504.745n 1.1v 504.755n 1.1v 509.745n 1.1v 509.755n 1.1v 514.745n 1.1v 514.755n 1.1v 519.745n 1.1v 519.755n 0.0v 524.745n 0.0v 524.755n 0.0v 529.745n 0.0v 529.755n 0.0v 534.745n 0.0v 534.755n 0.0v 539.745n 0.0v 539.755n 1.1v 544.745n 1.1v 544.755n 1.1v 549.745n 1.1v 549.755n 1.1v 554.745n 1.1v 554.755n 1.1v 559.745n 1.1v 559.755n 1.1v 564.745n 1.1v 564.755n 1.1v 569.745n 1.1v 569.755n 1.1v 574.745n 1.1v 574.755n 1.1v 579.745n 1.1v 579.755n 1.1v 584.745n 1.1v 584.755n 1.1v 589.745n 1.1v 589.755n 1.1v 594.745n 1.1v 594.755n 1.1v 599.745n 1.1v 599.755n 1.1v 604.745n 1.1v 604.755n 1.1v 609.745n 1.1v 609.755n 1.1v 614.745n 1.1v 614.755n 1.1v 619.745n 1.1v 619.755n 0.0v 624.745n 0.0v 624.755n 0.0v 629.745n 0.0v 629.755n 0.0v 634.745n 0.0v 634.755n 0.0v 639.745n 0.0v 639.755n 0.0v 644.745n 0.0v 644.755n 0.0v 649.745n 0.0v 649.755n 0.0v 654.745n 0.0v 654.755n 0.0v 659.745n 0.0v 659.755n 0.0v 664.745n 0.0v 664.755n 0.0v 669.745n 0.0v 669.755n 0.0v 674.745n 0.0v 674.755n 0.0v 679.745n 0.0v 679.755n 0.0v 684.745n 0.0v 684.755n 0.0v 689.745n 0.0v 689.755n 0.0v 694.745n 0.0v 694.755n 0.0v 699.745n 0.0v 699.755n 0.0v 704.745n 0.0v 704.755n 0.0v 709.745n 0.0v 709.755n 0.0v 714.745n 0.0v 714.755n 0.0v 719.745n 0.0v 719.755n 0.0v 724.745n 0.0v 724.755n 1.1v 729.745n 1.1v 729.755n 1.1v 734.745n 1.1v 734.755n 1.1v 739.745n 1.1v 739.755n 1.1v 744.745n 1.1v 744.755n 1.1v 749.745n 1.1v 749.755n 1.1v 754.745n 1.1v 754.755n 1.1v 759.745n 1.1v 759.755n 1.1v 764.745n 1.1v 764.755n 1.1v 769.745n 1.1v 769.755n 1.1v 774.745n 1.1v 774.755n 1.1v 779.745n 1.1v 779.755n 1.1v 784.745n 1.1v 784.755n 1.1v 789.745n 1.1v 789.755n 1.1v 794.745n 1.1v 794.755n 1.1v 799.745n 1.1v 799.755n 1.1v 804.745n 1.1v 804.755n 1.1v 809.745n 1.1v 809.755n 1.1v 814.745n 1.1v 814.755n 1.1v 819.745n 1.1v 819.755n 1.1v 824.745n 1.1v 824.755n 1.1v 829.745n 1.1v 829.755n 1.1v 834.745n 1.1v 834.755n 1.1v 839.745n 1.1v 839.755n 1.1v 844.745n 1.1v 844.755n 1.1v 849.745n 1.1v 849.755n 1.1v 854.745n 1.1v 854.755n 1.1v 859.745n 1.1v 859.755n 1.1v 864.745n 1.1v 864.755n 1.1v 869.745n 1.1v 869.755n 1.1v 874.745n 1.1v 874.755n 1.1v 879.745n 1.1v 879.755n 1.1v 884.745n 1.1v 884.755n 1.1v 889.745n 1.1v 889.755n 1.1v 894.745n 1.1v 894.755n 0.0v 899.745n 0.0v 899.755n 0.0v 904.745n 0.0v 904.755n 0.0v 909.745n 0.0v 909.755n 0.0v 914.745n 0.0v 914.755n 0.0v 919.745n 0.0v 919.755n 0.0v 924.745n 0.0v 924.755n 0.0v 929.745n 0.0v 929.755n 0.0v 934.745n 0.0v 934.755n 0.0v 939.745n 0.0v 939.755n 1.1v 944.745n 1.1v 944.755n 1.1v 949.745n 1.1v 949.755n 1.1v 954.745n 1.1v 954.755n 1.1v 959.745n 1.1v 959.755n 1.1v 964.745n 1.1v 964.755n 1.1v 969.745n 1.1v 969.755n 1.1v 974.745n 1.1v 974.755n 1.1v 979.745n 1.1v 979.755n 1.1v 984.745n 1.1v 984.755n 1.1v 989.745n 1.1v 989.755n 0.0v 994.745n 0.0v 994.755n 0.0v 999.745n 0.0v 999.755n 0.0v 1004.745n 0.0v 1004.755n 0.0v 1009.745n 0.0v 1009.755n 0.0v 1014.745n 0.0v 1014.755n 1.1v 1019.745n 1.1v 1019.755n 1.1v 1024.745n 1.1v 1024.755n 1.1v )
* (time, data): [(0, 0), (5, 1), (10, 0), (15, 1), (20, 1), (25, 1), (30, 0), (35, 1), (40, 1), (45, 1), (50, 1), (55, 1), (60, 0), (65, 0), (70, 1), (75, 1), (80, 1), (85, 1), (90, 1), (95, 1), (100, 0), (105, 0), (110, 0), (115, 1), (120, 1), (125, 0), (130, 0), (135, 1), (140, 1), (145, 0), (150, 0), (155, 0), (160, 0), (165, 1), (170, 1), (175, 1), (180, 1), (185, 1), (190, 1), (195, 1), (200, 1), (205, 1), (210, 1), (215, 1), (220, 0), (225, 0), (230, 1), (235, 1), (240, 1), (245, 1), (250, 1), (255, 1), (260, 1), (265, 1), (270, 0), (275, 0), (280, 0), (285, 1), (290, 1), (295, 1), (300, 1), (305, 1), (310, 1), (315, 1), (320, 1), (325, 0), (330, 1), (335, 1), (340, 1), (345, 1), (350, 1), (355, 1), (360, 1), (365, 1), (370, 0), (375, 1), (380, 1), (385, 0), (390, 0), (395, 0), (400, 0), (405, 0), (410, 0), (415, 0), (420, 1), (425, 1), (430, 1), (435, 1), (440, 1), (445, 1), (450, 1), (455, 1), (460, 1), (465, 1), (470, 1), (475, 1), (480, 0), (485, 1), (490, 1), (495, 0), (500, 0), (505, 0), (510, 0), (515, 0), (520, 1), (525, 1), (530, 1), (535, 1), (540, 1), (545, 1), (550, 1), (555, 1), (560, 1), (565, 1), (570, 0), (575, 0), (580, 0), (585, 0), (590, 0), (595, 0), (600, 0), (605, 0), (610, 0), (615, 0), (620, 0), (625, 0), (630, 0), (635, 0), (640, 0), (645, 0), (650, 1), (655, 0), (660, 0), (665, 0), (670, 0), (675, 0), (680, 0), (685, 0), (690, 1), (695, 1), (700, 1), (705, 1), (710, 1), (715, 1), (720, 1), (725, 0), (730, 0), (735, 0), (740, 0), (745, 0), (750, 0), (755, 0), (760, 0), (765, 0), (770, 0), (775, 0), (780, 0), (785, 0), (790, 0), (795, 1), (800, 1), (805, 1), (810, 1), (815, 1), (820, 1), (825, 1), (830, 1), (835, 1), (840, 0), (845, 0), (850, 0), (855, 0), (860, 0), (865, 0), (870, 1), (875, 1), (880, 1), (885, 1), (890, 1), (895, 1), (900, 1), (905, 1), (910, 1), (915, 1), (920, 0), (925, 0), (930, 0), (935, 0), (940, 1), (945, 1), (950, 1), (955, 1), (960, 1), (965, 1), (970, 1), (975, 1), (980, 1), (985, 0), (990, 0), (995, 0), (1000, 0), (1005, 0), (1010, 0), (1015, 1), (1020, 1), (1025, 1)]
Vdin0_4  din0_4  0 PWL (0n 0.0v 4.745n 0.0v 4.755n 1.1v 9.745n 1.1v 9.755n 0.0v 14.745n 0.0v 14.755n 1.1v 19.745n 1.1v 19.755n 1.1v 24.745n 1.1v 24.755n 1.1v 29.745n 1.1v 29.755n 0.0v 34.745n 0.0v 34.755n 1.1v 39.745n 1.1v 39.755n 1.1v 44.745n 1.1v 44.755n 1.1v 49.745n 1.1v 49.755n 1.1v 54.745n 1.1v 54.755n 1.1v 59.745n 1.1v 59.755n 0.0v 64.745n 0.0v 64.755n 0.0v 69.745n 0.0v 69.755n 1.1v 74.745n 1.1v 74.755n 1.1v 79.745n 1.1v 79.755n 1.1v 84.745n 1.1v 84.755n 1.1v 89.745n 1.1v 89.755n 1.1v 94.745n 1.1v 94.755n 1.1v 99.745n 1.1v 99.755n 0.0v 104.745n 0.0v 104.755n 0.0v 109.745n 0.0v 109.755n 0.0v 114.745n 0.0v 114.755n 1.1v 119.745n 1.1v 119.755n 1.1v 124.745n 1.1v 124.755n 0.0v 129.745n 0.0v 129.755n 0.0v 134.745n 0.0v 134.755n 1.1v 139.745n 1.1v 139.755n 1.1v 144.745n 1.1v 144.755n 0.0v 149.745n 0.0v 149.755n 0.0v 154.745n 0.0v 154.755n 0.0v 159.745n 0.0v 159.755n 0.0v 164.745n 0.0v 164.755n 1.1v 169.745n 1.1v 169.755n 1.1v 174.745n 1.1v 174.755n 1.1v 179.745n 1.1v 179.755n 1.1v 184.745n 1.1v 184.755n 1.1v 189.745n 1.1v 189.755n 1.1v 194.745n 1.1v 194.755n 1.1v 199.745n 1.1v 199.755n 1.1v 204.745n 1.1v 204.755n 1.1v 209.745n 1.1v 209.755n 1.1v 214.745n 1.1v 214.755n 1.1v 219.745n 1.1v 219.755n 0.0v 224.745n 0.0v 224.755n 0.0v 229.745n 0.0v 229.755n 1.1v 234.745n 1.1v 234.755n 1.1v 239.745n 1.1v 239.755n 1.1v 244.745n 1.1v 244.755n 1.1v 249.745n 1.1v 249.755n 1.1v 254.745n 1.1v 254.755n 1.1v 259.745n 1.1v 259.755n 1.1v 264.745n 1.1v 264.755n 1.1v 269.745n 1.1v 269.755n 0.0v 274.745n 0.0v 274.755n 0.0v 279.745n 0.0v 279.755n 0.0v 284.745n 0.0v 284.755n 1.1v 289.745n 1.1v 289.755n 1.1v 294.745n 1.1v 294.755n 1.1v 299.745n 1.1v 299.755n 1.1v 304.745n 1.1v 304.755n 1.1v 309.745n 1.1v 309.755n 1.1v 314.745n 1.1v 314.755n 1.1v 319.745n 1.1v 319.755n 1.1v 324.745n 1.1v 324.755n 0.0v 329.745n 0.0v 329.755n 1.1v 334.745n 1.1v 334.755n 1.1v 339.745n 1.1v 339.755n 1.1v 344.745n 1.1v 344.755n 1.1v 349.745n 1.1v 349.755n 1.1v 354.745n 1.1v 354.755n 1.1v 359.745n 1.1v 359.755n 1.1v 364.745n 1.1v 364.755n 1.1v 369.745n 1.1v 369.755n 0.0v 374.745n 0.0v 374.755n 1.1v 379.745n 1.1v 379.755n 1.1v 384.745n 1.1v 384.755n 0.0v 389.745n 0.0v 389.755n 0.0v 394.745n 0.0v 394.755n 0.0v 399.745n 0.0v 399.755n 0.0v 404.745n 0.0v 404.755n 0.0v 409.745n 0.0v 409.755n 0.0v 414.745n 0.0v 414.755n 0.0v 419.745n 0.0v 419.755n 1.1v 424.745n 1.1v 424.755n 1.1v 429.745n 1.1v 429.755n 1.1v 434.745n 1.1v 434.755n 1.1v 439.745n 1.1v 439.755n 1.1v 444.745n 1.1v 444.755n 1.1v 449.745n 1.1v 449.755n 1.1v 454.745n 1.1v 454.755n 1.1v 459.745n 1.1v 459.755n 1.1v 464.745n 1.1v 464.755n 1.1v 469.745n 1.1v 469.755n 1.1v 474.745n 1.1v 474.755n 1.1v 479.745n 1.1v 479.755n 0.0v 484.745n 0.0v 484.755n 1.1v 489.745n 1.1v 489.755n 1.1v 494.745n 1.1v 494.755n 0.0v 499.745n 0.0v 499.755n 0.0v 504.745n 0.0v 504.755n 0.0v 509.745n 0.0v 509.755n 0.0v 514.745n 0.0v 514.755n 0.0v 519.745n 0.0v 519.755n 1.1v 524.745n 1.1v 524.755n 1.1v 529.745n 1.1v 529.755n 1.1v 534.745n 1.1v 534.755n 1.1v 539.745n 1.1v 539.755n 1.1v 544.745n 1.1v 544.755n 1.1v 549.745n 1.1v 549.755n 1.1v 554.745n 1.1v 554.755n 1.1v 559.745n 1.1v 559.755n 1.1v 564.745n 1.1v 564.755n 1.1v 569.745n 1.1v 569.755n 0.0v 574.745n 0.0v 574.755n 0.0v 579.745n 0.0v 579.755n 0.0v 584.745n 0.0v 584.755n 0.0v 589.745n 0.0v 589.755n 0.0v 594.745n 0.0v 594.755n 0.0v 599.745n 0.0v 599.755n 0.0v 604.745n 0.0v 604.755n 0.0v 609.745n 0.0v 609.755n 0.0v 614.745n 0.0v 614.755n 0.0v 619.745n 0.0v 619.755n 0.0v 624.745n 0.0v 624.755n 0.0v 629.745n 0.0v 629.755n 0.0v 634.745n 0.0v 634.755n 0.0v 639.745n 0.0v 639.755n 0.0v 644.745n 0.0v 644.755n 0.0v 649.745n 0.0v 649.755n 1.1v 654.745n 1.1v 654.755n 0.0v 659.745n 0.0v 659.755n 0.0v 664.745n 0.0v 664.755n 0.0v 669.745n 0.0v 669.755n 0.0v 674.745n 0.0v 674.755n 0.0v 679.745n 0.0v 679.755n 0.0v 684.745n 0.0v 684.755n 0.0v 689.745n 0.0v 689.755n 1.1v 694.745n 1.1v 694.755n 1.1v 699.745n 1.1v 699.755n 1.1v 704.745n 1.1v 704.755n 1.1v 709.745n 1.1v 709.755n 1.1v 714.745n 1.1v 714.755n 1.1v 719.745n 1.1v 719.755n 1.1v 724.745n 1.1v 724.755n 0.0v 729.745n 0.0v 729.755n 0.0v 734.745n 0.0v 734.755n 0.0v 739.745n 0.0v 739.755n 0.0v 744.745n 0.0v 744.755n 0.0v 749.745n 0.0v 749.755n 0.0v 754.745n 0.0v 754.755n 0.0v 759.745n 0.0v 759.755n 0.0v 764.745n 0.0v 764.755n 0.0v 769.745n 0.0v 769.755n 0.0v 774.745n 0.0v 774.755n 0.0v 779.745n 0.0v 779.755n 0.0v 784.745n 0.0v 784.755n 0.0v 789.745n 0.0v 789.755n 0.0v 794.745n 0.0v 794.755n 1.1v 799.745n 1.1v 799.755n 1.1v 804.745n 1.1v 804.755n 1.1v 809.745n 1.1v 809.755n 1.1v 814.745n 1.1v 814.755n 1.1v 819.745n 1.1v 819.755n 1.1v 824.745n 1.1v 824.755n 1.1v 829.745n 1.1v 829.755n 1.1v 834.745n 1.1v 834.755n 1.1v 839.745n 1.1v 839.755n 0.0v 844.745n 0.0v 844.755n 0.0v 849.745n 0.0v 849.755n 0.0v 854.745n 0.0v 854.755n 0.0v 859.745n 0.0v 859.755n 0.0v 864.745n 0.0v 864.755n 0.0v 869.745n 0.0v 869.755n 1.1v 874.745n 1.1v 874.755n 1.1v 879.745n 1.1v 879.755n 1.1v 884.745n 1.1v 884.755n 1.1v 889.745n 1.1v 889.755n 1.1v 894.745n 1.1v 894.755n 1.1v 899.745n 1.1v 899.755n 1.1v 904.745n 1.1v 904.755n 1.1v 909.745n 1.1v 909.755n 1.1v 914.745n 1.1v 914.755n 1.1v 919.745n 1.1v 919.755n 0.0v 924.745n 0.0v 924.755n 0.0v 929.745n 0.0v 929.755n 0.0v 934.745n 0.0v 934.755n 0.0v 939.745n 0.0v 939.755n 1.1v 944.745n 1.1v 944.755n 1.1v 949.745n 1.1v 949.755n 1.1v 954.745n 1.1v 954.755n 1.1v 959.745n 1.1v 959.755n 1.1v 964.745n 1.1v 964.755n 1.1v 969.745n 1.1v 969.755n 1.1v 974.745n 1.1v 974.755n 1.1v 979.745n 1.1v 979.755n 1.1v 984.745n 1.1v 984.755n 0.0v 989.745n 0.0v 989.755n 0.0v 994.745n 0.0v 994.755n 0.0v 999.745n 0.0v 999.755n 0.0v 1004.745n 0.0v 1004.755n 0.0v 1009.745n 0.0v 1009.755n 0.0v 1014.745n 0.0v 1014.755n 1.1v 1019.745n 1.1v 1019.755n 1.1v 1024.745n 1.1v 1024.755n 1.1v )
* (time, data): [(0, 0), (5, 1), (10, 0), (15, 1), (20, 1), (25, 1), (30, 0), (35, 1), (40, 0), (45, 0), (50, 0), (55, 0), (60, 1), (65, 1), (70, 0), (75, 0), (80, 0), (85, 0), (90, 0), (95, 0), (100, 1), (105, 1), (110, 1), (115, 1), (120, 1), (125, 1), (130, 1), (135, 1), (140, 1), (145, 0), (150, 0), (155, 0), (160, 0), (165, 0), (170, 0), (175, 0), (180, 0), (185, 0), (190, 0), (195, 0), (200, 0), (205, 0), (210, 0), (215, 0), (220, 0), (225, 0), (230, 1), (235, 1), (240, 1), (245, 0), (250, 0), (255, 1), (260, 1), (265, 1), (270, 0), (275, 0), (280, 0), (285, 1), (290, 1), (295, 1), (300, 1), (305, 0), (310, 0), (315, 0), (320, 0), (325, 0), (330, 1), (335, 1), (340, 1), (345, 0), (350, 0), (355, 0), (360, 0), (365, 0), (370, 0), (375, 0), (380, 0), (385, 0), (390, 0), (395, 0), (400, 0), (405, 0), (410, 0), (415, 1), (420, 1), (425, 1), (430, 0), (435, 0), (440, 0), (445, 0), (450, 0), (455, 0), (460, 0), (465, 0), (470, 0), (475, 0), (480, 0), (485, 0), (490, 0), (495, 0), (500, 0), (505, 0), (510, 0), (515, 0), (520, 1), (525, 1), (530, 1), (535, 0), (540, 0), (545, 0), (550, 0), (555, 0), (560, 0), (565, 0), (570, 0), (575, 0), (580, 0), (585, 0), (590, 0), (595, 0), (600, 0), (605, 0), (610, 0), (615, 0), (620, 1), (625, 1), (630, 1), (635, 1), (640, 1), (645, 1), (650, 0), (655, 1), (660, 1), (665, 1), (670, 1), (675, 1), (680, 1), (685, 1), (690, 1), (695, 1), (700, 1), (705, 1), (710, 1), (715, 1), (720, 1), (725, 0), (730, 0), (735, 0), (740, 0), (745, 0), (750, 0), (755, 0), (760, 0), (765, 0), (770, 0), (775, 0), (780, 0), (785, 0), (790, 0), (795, 1), (800, 1), (805, 1), (810, 1), (815, 1), (820, 1), (825, 1), (830, 1), (835, 1), (840, 1), (845, 1), (850, 1), (855, 1), (860, 1), (865, 1), (870, 0), (875, 0), (880, 0), (885, 0), (890, 0), (895, 1), (900, 1), (905, 1), (910, 1), (915, 1), (920, 0), (925, 0), (930, 0), (935, 0), (940, 0), (945, 0), (950, 0), (955, 0), (960, 0), (965, 0), (970, 0), (975, 0), (980, 0), (985, 1), (990, 0), (995, 0), (1000, 0), (1005, 0), (1010, 0), (1015, 1), (1020, 1), (1025, 1)]
Vdin0_5  din0_5  0 PWL (0n 0.0v 4.745n 0.0v 4.755n 1.1v 9.745n 1.1v 9.755n 0.0v 14.745n 0.0v 14.755n 1.1v 19.745n 1.1v 19.755n 1.1v 24.745n 1.1v 24.755n 1.1v 29.745n 1.1v 29.755n 0.0v 34.745n 0.0v 34.755n 1.1v 39.745n 1.1v 39.755n 0.0v 44.745n 0.0v 44.755n 0.0v 49.745n 0.0v 49.755n 0.0v 54.745n 0.0v 54.755n 0.0v 59.745n 0.0v 59.755n 1.1v 64.745n 1.1v 64.755n 1.1v 69.745n 1.1v 69.755n 0.0v 74.745n 0.0v 74.755n 0.0v 79.745n 0.0v 79.755n 0.0v 84.745n 0.0v 84.755n 0.0v 89.745n 0.0v 89.755n 0.0v 94.745n 0.0v 94.755n 0.0v 99.745n 0.0v 99.755n 1.1v 104.745n 1.1v 104.755n 1.1v 109.745n 1.1v 109.755n 1.1v 114.745n 1.1v 114.755n 1.1v 119.745n 1.1v 119.755n 1.1v 124.745n 1.1v 124.755n 1.1v 129.745n 1.1v 129.755n 1.1v 134.745n 1.1v 134.755n 1.1v 139.745n 1.1v 139.755n 1.1v 144.745n 1.1v 144.755n 0.0v 149.745n 0.0v 149.755n 0.0v 154.745n 0.0v 154.755n 0.0v 159.745n 0.0v 159.755n 0.0v 164.745n 0.0v 164.755n 0.0v 169.745n 0.0v 169.755n 0.0v 174.745n 0.0v 174.755n 0.0v 179.745n 0.0v 179.755n 0.0v 184.745n 0.0v 184.755n 0.0v 189.745n 0.0v 189.755n 0.0v 194.745n 0.0v 194.755n 0.0v 199.745n 0.0v 199.755n 0.0v 204.745n 0.0v 204.755n 0.0v 209.745n 0.0v 209.755n 0.0v 214.745n 0.0v 214.755n 0.0v 219.745n 0.0v 219.755n 0.0v 224.745n 0.0v 224.755n 0.0v 229.745n 0.0v 229.755n 1.1v 234.745n 1.1v 234.755n 1.1v 239.745n 1.1v 239.755n 1.1v 244.745n 1.1v 244.755n 0.0v 249.745n 0.0v 249.755n 0.0v 254.745n 0.0v 254.755n 1.1v 259.745n 1.1v 259.755n 1.1v 264.745n 1.1v 264.755n 1.1v 269.745n 1.1v 269.755n 0.0v 274.745n 0.0v 274.755n 0.0v 279.745n 0.0v 279.755n 0.0v 284.745n 0.0v 284.755n 1.1v 289.745n 1.1v 289.755n 1.1v 294.745n 1.1v 294.755n 1.1v 299.745n 1.1v 299.755n 1.1v 304.745n 1.1v 304.755n 0.0v 309.745n 0.0v 309.755n 0.0v 314.745n 0.0v 314.755n 0.0v 319.745n 0.0v 319.755n 0.0v 324.745n 0.0v 324.755n 0.0v 329.745n 0.0v 329.755n 1.1v 334.745n 1.1v 334.755n 1.1v 339.745n 1.1v 339.755n 1.1v 344.745n 1.1v 344.755n 0.0v 349.745n 0.0v 349.755n 0.0v 354.745n 0.0v 354.755n 0.0v 359.745n 0.0v 359.755n 0.0v 364.745n 0.0v 364.755n 0.0v 369.745n 0.0v 369.755n 0.0v 374.745n 0.0v 374.755n 0.0v 379.745n 0.0v 379.755n 0.0v 384.745n 0.0v 384.755n 0.0v 389.745n 0.0v 389.755n 0.0v 394.745n 0.0v 394.755n 0.0v 399.745n 0.0v 399.755n 0.0v 404.745n 0.0v 404.755n 0.0v 409.745n 0.0v 409.755n 0.0v 414.745n 0.0v 414.755n 1.1v 419.745n 1.1v 419.755n 1.1v 424.745n 1.1v 424.755n 1.1v 429.745n 1.1v 429.755n 0.0v 434.745n 0.0v 434.755n 0.0v 439.745n 0.0v 439.755n 0.0v 444.745n 0.0v 444.755n 0.0v 449.745n 0.0v 449.755n 0.0v 454.745n 0.0v 454.755n 0.0v 459.745n 0.0v 459.755n 0.0v 464.745n 0.0v 464.755n 0.0v 469.745n 0.0v 469.755n 0.0v 474.745n 0.0v 474.755n 0.0v 479.745n 0.0v 479.755n 0.0v 484.745n 0.0v 484.755n 0.0v 489.745n 0.0v 489.755n 0.0v 494.745n 0.0v 494.755n 0.0v 499.745n 0.0v 499.755n 0.0v 504.745n 0.0v 504.755n 0.0v 509.745n 0.0v 509.755n 0.0v 514.745n 0.0v 514.755n 0.0v 519.745n 0.0v 519.755n 1.1v 524.745n 1.1v 524.755n 1.1v 529.745n 1.1v 529.755n 1.1v 534.745n 1.1v 534.755n 0.0v 539.745n 0.0v 539.755n 0.0v 544.745n 0.0v 544.755n 0.0v 549.745n 0.0v 549.755n 0.0v 554.745n 0.0v 554.755n 0.0v 559.745n 0.0v 559.755n 0.0v 564.745n 0.0v 564.755n 0.0v 569.745n 0.0v 569.755n 0.0v 574.745n 0.0v 574.755n 0.0v 579.745n 0.0v 579.755n 0.0v 584.745n 0.0v 584.755n 0.0v 589.745n 0.0v 589.755n 0.0v 594.745n 0.0v 594.755n 0.0v 599.745n 0.0v 599.755n 0.0v 604.745n 0.0v 604.755n 0.0v 609.745n 0.0v 609.755n 0.0v 614.745n 0.0v 614.755n 0.0v 619.745n 0.0v 619.755n 1.1v 624.745n 1.1v 624.755n 1.1v 629.745n 1.1v 629.755n 1.1v 634.745n 1.1v 634.755n 1.1v 639.745n 1.1v 639.755n 1.1v 644.745n 1.1v 644.755n 1.1v 649.745n 1.1v 649.755n 0.0v 654.745n 0.0v 654.755n 1.1v 659.745n 1.1v 659.755n 1.1v 664.745n 1.1v 664.755n 1.1v 669.745n 1.1v 669.755n 1.1v 674.745n 1.1v 674.755n 1.1v 679.745n 1.1v 679.755n 1.1v 684.745n 1.1v 684.755n 1.1v 689.745n 1.1v 689.755n 1.1v 694.745n 1.1v 694.755n 1.1v 699.745n 1.1v 699.755n 1.1v 704.745n 1.1v 704.755n 1.1v 709.745n 1.1v 709.755n 1.1v 714.745n 1.1v 714.755n 1.1v 719.745n 1.1v 719.755n 1.1v 724.745n 1.1v 724.755n 0.0v 729.745n 0.0v 729.755n 0.0v 734.745n 0.0v 734.755n 0.0v 739.745n 0.0v 739.755n 0.0v 744.745n 0.0v 744.755n 0.0v 749.745n 0.0v 749.755n 0.0v 754.745n 0.0v 754.755n 0.0v 759.745n 0.0v 759.755n 0.0v 764.745n 0.0v 764.755n 0.0v 769.745n 0.0v 769.755n 0.0v 774.745n 0.0v 774.755n 0.0v 779.745n 0.0v 779.755n 0.0v 784.745n 0.0v 784.755n 0.0v 789.745n 0.0v 789.755n 0.0v 794.745n 0.0v 794.755n 1.1v 799.745n 1.1v 799.755n 1.1v 804.745n 1.1v 804.755n 1.1v 809.745n 1.1v 809.755n 1.1v 814.745n 1.1v 814.755n 1.1v 819.745n 1.1v 819.755n 1.1v 824.745n 1.1v 824.755n 1.1v 829.745n 1.1v 829.755n 1.1v 834.745n 1.1v 834.755n 1.1v 839.745n 1.1v 839.755n 1.1v 844.745n 1.1v 844.755n 1.1v 849.745n 1.1v 849.755n 1.1v 854.745n 1.1v 854.755n 1.1v 859.745n 1.1v 859.755n 1.1v 864.745n 1.1v 864.755n 1.1v 869.745n 1.1v 869.755n 0.0v 874.745n 0.0v 874.755n 0.0v 879.745n 0.0v 879.755n 0.0v 884.745n 0.0v 884.755n 0.0v 889.745n 0.0v 889.755n 0.0v 894.745n 0.0v 894.755n 1.1v 899.745n 1.1v 899.755n 1.1v 904.745n 1.1v 904.755n 1.1v 909.745n 1.1v 909.755n 1.1v 914.745n 1.1v 914.755n 1.1v 919.745n 1.1v 919.755n 0.0v 924.745n 0.0v 924.755n 0.0v 929.745n 0.0v 929.755n 0.0v 934.745n 0.0v 934.755n 0.0v 939.745n 0.0v 939.755n 0.0v 944.745n 0.0v 944.755n 0.0v 949.745n 0.0v 949.755n 0.0v 954.745n 0.0v 954.755n 0.0v 959.745n 0.0v 959.755n 0.0v 964.745n 0.0v 964.755n 0.0v 969.745n 0.0v 969.755n 0.0v 974.745n 0.0v 974.755n 0.0v 979.745n 0.0v 979.755n 0.0v 984.745n 0.0v 984.755n 1.1v 989.745n 1.1v 989.755n 0.0v 994.745n 0.0v 994.755n 0.0v 999.745n 0.0v 999.755n 0.0v 1004.745n 0.0v 1004.755n 0.0v 1009.745n 0.0v 1009.755n 0.0v 1014.745n 0.0v 1014.755n 1.1v 1019.745n 1.1v 1019.755n 1.1v 1024.745n 1.1v 1024.755n 1.1v )
* (time, data): [(0, 0), (5, 1), (10, 0), (15, 1), (20, 1), (25, 1), (30, 0), (35, 0), (40, 1), (45, 1), (50, 1), (55, 1), (60, 0), (65, 0), (70, 1), (75, 1), (80, 1), (85, 1), (90, 1), (95, 1), (100, 1), (105, 1), (110, 1), (115, 1), (120, 1), (125, 0), (130, 0), (135, 1), (140, 0), (145, 0), (150, 0), (155, 0), (160, 0), (165, 0), (170, 0), (175, 0), (180, 0), (185, 0), (190, 0), (195, 0), (200, 0), (205, 0), (210, 0), (215, 0), (220, 1), (225, 1), (230, 0), (235, 0), (240, 0), (245, 1), (250, 1), (255, 1), (260, 1), (265, 1), (270, 1), (275, 1), (280, 1), (285, 0), (290, 0), (295, 0), (300, 0), (305, 1), (310, 1), (315, 1), (320, 1), (325, 0), (330, 0), (335, 0), (340, 0), (345, 0), (350, 0), (355, 0), (360, 0), (365, 0), (370, 0), (375, 1), (380, 1), (385, 1), (390, 1), (395, 1), (400, 1), (405, 1), (410, 1), (415, 1), (420, 0), (425, 0), (430, 0), (435, 0), (440, 0), (445, 0), (450, 0), (455, 0), (460, 0), (465, 0), (470, 0), (475, 0), (480, 0), (485, 1), (490, 1), (495, 1), (500, 1), (505, 1), (510, 1), (515, 1), (520, 1), (525, 1), (530, 1), (535, 0), (540, 0), (545, 0), (550, 0), (555, 1), (560, 1), (565, 1), (570, 1), (575, 1), (580, 1), (585, 0), (590, 0), (595, 0), (600, 1), (605, 1), (610, 1), (615, 1), (620, 0), (625, 0), (630, 0), (635, 0), (640, 0), (645, 0), (650, 0), (655, 0), (660, 0), (665, 0), (670, 0), (675, 0), (680, 0), (685, 0), (690, 0), (695, 0), (700, 0), (705, 0), (710, 0), (715, 1), (720, 1), (725, 1), (730, 1), (735, 1), (740, 1), (745, 1), (750, 1), (755, 1), (760, 1), (765, 1), (770, 1), (775, 1), (780, 1), (785, 1), (790, 1), (795, 0), (800, 0), (805, 0), (810, 0), (815, 0), (820, 0), (825, 0), (830, 0), (835, 0), (840, 0), (845, 0), (850, 0), (855, 0), (860, 0), (865, 0), (870, 1), (875, 1), (880, 1), (885, 1), (890, 1), (895, 0), (900, 0), (905, 0), (910, 0), (915, 0), (920, 0), (925, 0), (930, 0), (935, 0), (940, 1), (945, 1), (950, 1), (955, 1), (960, 1), (965, 1), (970, 1), (975, 1), (980, 1), (985, 1), (990, 1), (995, 1), (1000, 1), (1005, 1), (1010, 1), (1015, 1), (1020, 0), (1025, 0)]
Vdin0_6  din0_6  0 PWL (0n 0.0v 4.745n 0.0v 4.755n 1.1v 9.745n 1.1v 9.755n 0.0v 14.745n 0.0v 14.755n 1.1v 19.745n 1.1v 19.755n 1.1v 24.745n 1.1v 24.755n 1.1v 29.745n 1.1v 29.755n 0.0v 34.745n 0.0v 34.755n 0.0v 39.745n 0.0v 39.755n 1.1v 44.745n 1.1v 44.755n 1.1v 49.745n 1.1v 49.755n 1.1v 54.745n 1.1v 54.755n 1.1v 59.745n 1.1v 59.755n 0.0v 64.745n 0.0v 64.755n 0.0v 69.745n 0.0v 69.755n 1.1v 74.745n 1.1v 74.755n 1.1v 79.745n 1.1v 79.755n 1.1v 84.745n 1.1v 84.755n 1.1v 89.745n 1.1v 89.755n 1.1v 94.745n 1.1v 94.755n 1.1v 99.745n 1.1v 99.755n 1.1v 104.745n 1.1v 104.755n 1.1v 109.745n 1.1v 109.755n 1.1v 114.745n 1.1v 114.755n 1.1v 119.745n 1.1v 119.755n 1.1v 124.745n 1.1v 124.755n 0.0v 129.745n 0.0v 129.755n 0.0v 134.745n 0.0v 134.755n 1.1v 139.745n 1.1v 139.755n 0.0v 144.745n 0.0v 144.755n 0.0v 149.745n 0.0v 149.755n 0.0v 154.745n 0.0v 154.755n 0.0v 159.745n 0.0v 159.755n 0.0v 164.745n 0.0v 164.755n 0.0v 169.745n 0.0v 169.755n 0.0v 174.745n 0.0v 174.755n 0.0v 179.745n 0.0v 179.755n 0.0v 184.745n 0.0v 184.755n 0.0v 189.745n 0.0v 189.755n 0.0v 194.745n 0.0v 194.755n 0.0v 199.745n 0.0v 199.755n 0.0v 204.745n 0.0v 204.755n 0.0v 209.745n 0.0v 209.755n 0.0v 214.745n 0.0v 214.755n 0.0v 219.745n 0.0v 219.755n 1.1v 224.745n 1.1v 224.755n 1.1v 229.745n 1.1v 229.755n 0.0v 234.745n 0.0v 234.755n 0.0v 239.745n 0.0v 239.755n 0.0v 244.745n 0.0v 244.755n 1.1v 249.745n 1.1v 249.755n 1.1v 254.745n 1.1v 254.755n 1.1v 259.745n 1.1v 259.755n 1.1v 264.745n 1.1v 264.755n 1.1v 269.745n 1.1v 269.755n 1.1v 274.745n 1.1v 274.755n 1.1v 279.745n 1.1v 279.755n 1.1v 284.745n 1.1v 284.755n 0.0v 289.745n 0.0v 289.755n 0.0v 294.745n 0.0v 294.755n 0.0v 299.745n 0.0v 299.755n 0.0v 304.745n 0.0v 304.755n 1.1v 309.745n 1.1v 309.755n 1.1v 314.745n 1.1v 314.755n 1.1v 319.745n 1.1v 319.755n 1.1v 324.745n 1.1v 324.755n 0.0v 329.745n 0.0v 329.755n 0.0v 334.745n 0.0v 334.755n 0.0v 339.745n 0.0v 339.755n 0.0v 344.745n 0.0v 344.755n 0.0v 349.745n 0.0v 349.755n 0.0v 354.745n 0.0v 354.755n 0.0v 359.745n 0.0v 359.755n 0.0v 364.745n 0.0v 364.755n 0.0v 369.745n 0.0v 369.755n 0.0v 374.745n 0.0v 374.755n 1.1v 379.745n 1.1v 379.755n 1.1v 384.745n 1.1v 384.755n 1.1v 389.745n 1.1v 389.755n 1.1v 394.745n 1.1v 394.755n 1.1v 399.745n 1.1v 399.755n 1.1v 404.745n 1.1v 404.755n 1.1v 409.745n 1.1v 409.755n 1.1v 414.745n 1.1v 414.755n 1.1v 419.745n 1.1v 419.755n 0.0v 424.745n 0.0v 424.755n 0.0v 429.745n 0.0v 429.755n 0.0v 434.745n 0.0v 434.755n 0.0v 439.745n 0.0v 439.755n 0.0v 444.745n 0.0v 444.755n 0.0v 449.745n 0.0v 449.755n 0.0v 454.745n 0.0v 454.755n 0.0v 459.745n 0.0v 459.755n 0.0v 464.745n 0.0v 464.755n 0.0v 469.745n 0.0v 469.755n 0.0v 474.745n 0.0v 474.755n 0.0v 479.745n 0.0v 479.755n 0.0v 484.745n 0.0v 484.755n 1.1v 489.745n 1.1v 489.755n 1.1v 494.745n 1.1v 494.755n 1.1v 499.745n 1.1v 499.755n 1.1v 504.745n 1.1v 504.755n 1.1v 509.745n 1.1v 509.755n 1.1v 514.745n 1.1v 514.755n 1.1v 519.745n 1.1v 519.755n 1.1v 524.745n 1.1v 524.755n 1.1v 529.745n 1.1v 529.755n 1.1v 534.745n 1.1v 534.755n 0.0v 539.745n 0.0v 539.755n 0.0v 544.745n 0.0v 544.755n 0.0v 549.745n 0.0v 549.755n 0.0v 554.745n 0.0v 554.755n 1.1v 559.745n 1.1v 559.755n 1.1v 564.745n 1.1v 564.755n 1.1v 569.745n 1.1v 569.755n 1.1v 574.745n 1.1v 574.755n 1.1v 579.745n 1.1v 579.755n 1.1v 584.745n 1.1v 584.755n 0.0v 589.745n 0.0v 589.755n 0.0v 594.745n 0.0v 594.755n 0.0v 599.745n 0.0v 599.755n 1.1v 604.745n 1.1v 604.755n 1.1v 609.745n 1.1v 609.755n 1.1v 614.745n 1.1v 614.755n 1.1v 619.745n 1.1v 619.755n 0.0v 624.745n 0.0v 624.755n 0.0v 629.745n 0.0v 629.755n 0.0v 634.745n 0.0v 634.755n 0.0v 639.745n 0.0v 639.755n 0.0v 644.745n 0.0v 644.755n 0.0v 649.745n 0.0v 649.755n 0.0v 654.745n 0.0v 654.755n 0.0v 659.745n 0.0v 659.755n 0.0v 664.745n 0.0v 664.755n 0.0v 669.745n 0.0v 669.755n 0.0v 674.745n 0.0v 674.755n 0.0v 679.745n 0.0v 679.755n 0.0v 684.745n 0.0v 684.755n 0.0v 689.745n 0.0v 689.755n 0.0v 694.745n 0.0v 694.755n 0.0v 699.745n 0.0v 699.755n 0.0v 704.745n 0.0v 704.755n 0.0v 709.745n 0.0v 709.755n 0.0v 714.745n 0.0v 714.755n 1.1v 719.745n 1.1v 719.755n 1.1v 724.745n 1.1v 724.755n 1.1v 729.745n 1.1v 729.755n 1.1v 734.745n 1.1v 734.755n 1.1v 739.745n 1.1v 739.755n 1.1v 744.745n 1.1v 744.755n 1.1v 749.745n 1.1v 749.755n 1.1v 754.745n 1.1v 754.755n 1.1v 759.745n 1.1v 759.755n 1.1v 764.745n 1.1v 764.755n 1.1v 769.745n 1.1v 769.755n 1.1v 774.745n 1.1v 774.755n 1.1v 779.745n 1.1v 779.755n 1.1v 784.745n 1.1v 784.755n 1.1v 789.745n 1.1v 789.755n 1.1v 794.745n 1.1v 794.755n 0.0v 799.745n 0.0v 799.755n 0.0v 804.745n 0.0v 804.755n 0.0v 809.745n 0.0v 809.755n 0.0v 814.745n 0.0v 814.755n 0.0v 819.745n 0.0v 819.755n 0.0v 824.745n 0.0v 824.755n 0.0v 829.745n 0.0v 829.755n 0.0v 834.745n 0.0v 834.755n 0.0v 839.745n 0.0v 839.755n 0.0v 844.745n 0.0v 844.755n 0.0v 849.745n 0.0v 849.755n 0.0v 854.745n 0.0v 854.755n 0.0v 859.745n 0.0v 859.755n 0.0v 864.745n 0.0v 864.755n 0.0v 869.745n 0.0v 869.755n 1.1v 874.745n 1.1v 874.755n 1.1v 879.745n 1.1v 879.755n 1.1v 884.745n 1.1v 884.755n 1.1v 889.745n 1.1v 889.755n 1.1v 894.745n 1.1v 894.755n 0.0v 899.745n 0.0v 899.755n 0.0v 904.745n 0.0v 904.755n 0.0v 909.745n 0.0v 909.755n 0.0v 914.745n 0.0v 914.755n 0.0v 919.745n 0.0v 919.755n 0.0v 924.745n 0.0v 924.755n 0.0v 929.745n 0.0v 929.755n 0.0v 934.745n 0.0v 934.755n 0.0v 939.745n 0.0v 939.755n 1.1v 944.745n 1.1v 944.755n 1.1v 949.745n 1.1v 949.755n 1.1v 954.745n 1.1v 954.755n 1.1v 959.745n 1.1v 959.755n 1.1v 964.745n 1.1v 964.755n 1.1v 969.745n 1.1v 969.755n 1.1v 974.745n 1.1v 974.755n 1.1v 979.745n 1.1v 979.755n 1.1v 984.745n 1.1v 984.755n 1.1v 989.745n 1.1v 989.755n 1.1v 994.745n 1.1v 994.755n 1.1v 999.745n 1.1v 999.755n 1.1v 1004.745n 1.1v 1004.755n 1.1v 1009.745n 1.1v 1009.755n 1.1v 1014.745n 1.1v 1014.755n 1.1v 1019.745n 1.1v 1019.755n 0.0v 1024.745n 0.0v 1024.755n 0.0v )
* (time, data): [(0, 0), (5, 0), (10, 0), (15, 0), (20, 0), (25, 0), (30, 0), (35, 0), (40, 1), (45, 1), (50, 1), (55, 1), (60, 1), (65, 1), (70, 1), (75, 1), (80, 1), (85, 1), (90, 1), (95, 1), (100, 0), (105, 0), (110, 0), (115, 0), (120, 0), (125, 0), (130, 0), (135, 0), (140, 0), (145, 0), (150, 0), (155, 0), (160, 0), (165, 0), (170, 0), (175, 0), (180, 0), (185, 0), (190, 0), (195, 0), (200, 0), (205, 0), (210, 0), (215, 0), (220, 1), (225, 1), (230, 1), (235, 1), (240, 1), (245, 1), (250, 1), (255, 0), (260, 0), (265, 0), (270, 1), (275, 1), (280, 1), (285, 1), (290, 1), (295, 1), (300, 1), (305, 0), (310, 0), (315, 0), (320, 0), (325, 1), (330, 0), (335, 0), (340, 0), (345, 1), (350, 1), (355, 1), (360, 1), (365, 1), (370, 1), (375, 0), (380, 0), (385, 1), (390, 1), (395, 1), (400, 1), (405, 1), (410, 1), (415, 0), (420, 0), (425, 0), (430, 1), (435, 1), (440, 1), (445, 1), (450, 1), (455, 1), (460, 1), (465, 1), (470, 1), (475, 1), (480, 1), (485, 1), (490, 1), (495, 1), (500, 1), (505, 1), (510, 1), (515, 1), (520, 1), (525, 1), (530, 1), (535, 1), (540, 0), (545, 0), (550, 0), (555, 0), (560, 0), (565, 0), (570, 0), (575, 0), (580, 0), (585, 0), (590, 0), (595, 0), (600, 1), (605, 1), (610, 1), (615, 1), (620, 1), (625, 1), (630, 1), (635, 1), (640, 1), (645, 1), (650, 1), (655, 0), (660, 0), (665, 0), (670, 0), (675, 0), (680, 0), (685, 0), (690, 0), (695, 0), (700, 0), (705, 0), (710, 0), (715, 1), (720, 1), (725, 1), (730, 1), (735, 1), (740, 1), (745, 1), (750, 1), (755, 1), (760, 1), (765, 1), (770, 1), (775, 1), (780, 1), (785, 1), (790, 1), (795, 0), (800, 0), (805, 0), (810, 0), (815, 0), (820, 0), (825, 0), (830, 0), (835, 0), (840, 0), (845, 0), (850, 0), (855, 0), (860, 0), (865, 0), (870, 1), (875, 1), (880, 1), (885, 1), (890, 1), (895, 1), (900, 1), (905, 1), (910, 1), (915, 1), (920, 0), (925, 0), (930, 0), (935, 0), (940, 0), (945, 0), (950, 0), (955, 0), (960, 0), (965, 0), (970, 0), (975, 0), (980, 0), (985, 1), (990, 1), (995, 1), (1000, 1), (1005, 1), (1010, 1), (1015, 0), (1020, 1), (1025, 1)]
Vdin0_7  din0_7  0 PWL (0n 0.0v 4.745n 0.0v 4.755n 0.0v 9.745n 0.0v 9.755n 0.0v 14.745n 0.0v 14.755n 0.0v 19.745n 0.0v 19.755n 0.0v 24.745n 0.0v 24.755n 0.0v 29.745n 0.0v 29.755n 0.0v 34.745n 0.0v 34.755n 0.0v 39.745n 0.0v 39.755n 1.1v 44.745n 1.1v 44.755n 1.1v 49.745n 1.1v 49.755n 1.1v 54.745n 1.1v 54.755n 1.1v 59.745n 1.1v 59.755n 1.1v 64.745n 1.1v 64.755n 1.1v 69.745n 1.1v 69.755n 1.1v 74.745n 1.1v 74.755n 1.1v 79.745n 1.1v 79.755n 1.1v 84.745n 1.1v 84.755n 1.1v 89.745n 1.1v 89.755n 1.1v 94.745n 1.1v 94.755n 1.1v 99.745n 1.1v 99.755n 0.0v 104.745n 0.0v 104.755n 0.0v 109.745n 0.0v 109.755n 0.0v 114.745n 0.0v 114.755n 0.0v 119.745n 0.0v 119.755n 0.0v 124.745n 0.0v 124.755n 0.0v 129.745n 0.0v 129.755n 0.0v 134.745n 0.0v 134.755n 0.0v 139.745n 0.0v 139.755n 0.0v 144.745n 0.0v 144.755n 0.0v 149.745n 0.0v 149.755n 0.0v 154.745n 0.0v 154.755n 0.0v 159.745n 0.0v 159.755n 0.0v 164.745n 0.0v 164.755n 0.0v 169.745n 0.0v 169.755n 0.0v 174.745n 0.0v 174.755n 0.0v 179.745n 0.0v 179.755n 0.0v 184.745n 0.0v 184.755n 0.0v 189.745n 0.0v 189.755n 0.0v 194.745n 0.0v 194.755n 0.0v 199.745n 0.0v 199.755n 0.0v 204.745n 0.0v 204.755n 0.0v 209.745n 0.0v 209.755n 0.0v 214.745n 0.0v 214.755n 0.0v 219.745n 0.0v 219.755n 1.1v 224.745n 1.1v 224.755n 1.1v 229.745n 1.1v 229.755n 1.1v 234.745n 1.1v 234.755n 1.1v 239.745n 1.1v 239.755n 1.1v 244.745n 1.1v 244.755n 1.1v 249.745n 1.1v 249.755n 1.1v 254.745n 1.1v 254.755n 0.0v 259.745n 0.0v 259.755n 0.0v 264.745n 0.0v 264.755n 0.0v 269.745n 0.0v 269.755n 1.1v 274.745n 1.1v 274.755n 1.1v 279.745n 1.1v 279.755n 1.1v 284.745n 1.1v 284.755n 1.1v 289.745n 1.1v 289.755n 1.1v 294.745n 1.1v 294.755n 1.1v 299.745n 1.1v 299.755n 1.1v 304.745n 1.1v 304.755n 0.0v 309.745n 0.0v 309.755n 0.0v 314.745n 0.0v 314.755n 0.0v 319.745n 0.0v 319.755n 0.0v 324.745n 0.0v 324.755n 1.1v 329.745n 1.1v 329.755n 0.0v 334.745n 0.0v 334.755n 0.0v 339.745n 0.0v 339.755n 0.0v 344.745n 0.0v 344.755n 1.1v 349.745n 1.1v 349.755n 1.1v 354.745n 1.1v 354.755n 1.1v 359.745n 1.1v 359.755n 1.1v 364.745n 1.1v 364.755n 1.1v 369.745n 1.1v 369.755n 1.1v 374.745n 1.1v 374.755n 0.0v 379.745n 0.0v 379.755n 0.0v 384.745n 0.0v 384.755n 1.1v 389.745n 1.1v 389.755n 1.1v 394.745n 1.1v 394.755n 1.1v 399.745n 1.1v 399.755n 1.1v 404.745n 1.1v 404.755n 1.1v 409.745n 1.1v 409.755n 1.1v 414.745n 1.1v 414.755n 0.0v 419.745n 0.0v 419.755n 0.0v 424.745n 0.0v 424.755n 0.0v 429.745n 0.0v 429.755n 1.1v 434.745n 1.1v 434.755n 1.1v 439.745n 1.1v 439.755n 1.1v 444.745n 1.1v 444.755n 1.1v 449.745n 1.1v 449.755n 1.1v 454.745n 1.1v 454.755n 1.1v 459.745n 1.1v 459.755n 1.1v 464.745n 1.1v 464.755n 1.1v 469.745n 1.1v 469.755n 1.1v 474.745n 1.1v 474.755n 1.1v 479.745n 1.1v 479.755n 1.1v 484.745n 1.1v 484.755n 1.1v 489.745n 1.1v 489.755n 1.1v 494.745n 1.1v 494.755n 1.1v 499.745n 1.1v 499.755n 1.1v 504.745n 1.1v 504.755n 1.1v 509.745n 1.1v 509.755n 1.1v 514.745n 1.1v 514.755n 1.1v 519.745n 1.1v 519.755n 1.1v 524.745n 1.1v 524.755n 1.1v 529.745n 1.1v 529.755n 1.1v 534.745n 1.1v 534.755n 1.1v 539.745n 1.1v 539.755n 0.0v 544.745n 0.0v 544.755n 0.0v 549.745n 0.0v 549.755n 0.0v 554.745n 0.0v 554.755n 0.0v 559.745n 0.0v 559.755n 0.0v 564.745n 0.0v 564.755n 0.0v 569.745n 0.0v 569.755n 0.0v 574.745n 0.0v 574.755n 0.0v 579.745n 0.0v 579.755n 0.0v 584.745n 0.0v 584.755n 0.0v 589.745n 0.0v 589.755n 0.0v 594.745n 0.0v 594.755n 0.0v 599.745n 0.0v 599.755n 1.1v 604.745n 1.1v 604.755n 1.1v 609.745n 1.1v 609.755n 1.1v 614.745n 1.1v 614.755n 1.1v 619.745n 1.1v 619.755n 1.1v 624.745n 1.1v 624.755n 1.1v 629.745n 1.1v 629.755n 1.1v 634.745n 1.1v 634.755n 1.1v 639.745n 1.1v 639.755n 1.1v 644.745n 1.1v 644.755n 1.1v 649.745n 1.1v 649.755n 1.1v 654.745n 1.1v 654.755n 0.0v 659.745n 0.0v 659.755n 0.0v 664.745n 0.0v 664.755n 0.0v 669.745n 0.0v 669.755n 0.0v 674.745n 0.0v 674.755n 0.0v 679.745n 0.0v 679.755n 0.0v 684.745n 0.0v 684.755n 0.0v 689.745n 0.0v 689.755n 0.0v 694.745n 0.0v 694.755n 0.0v 699.745n 0.0v 699.755n 0.0v 704.745n 0.0v 704.755n 0.0v 709.745n 0.0v 709.755n 0.0v 714.745n 0.0v 714.755n 1.1v 719.745n 1.1v 719.755n 1.1v 724.745n 1.1v 724.755n 1.1v 729.745n 1.1v 729.755n 1.1v 734.745n 1.1v 734.755n 1.1v 739.745n 1.1v 739.755n 1.1v 744.745n 1.1v 744.755n 1.1v 749.745n 1.1v 749.755n 1.1v 754.745n 1.1v 754.755n 1.1v 759.745n 1.1v 759.755n 1.1v 764.745n 1.1v 764.755n 1.1v 769.745n 1.1v 769.755n 1.1v 774.745n 1.1v 774.755n 1.1v 779.745n 1.1v 779.755n 1.1v 784.745n 1.1v 784.755n 1.1v 789.745n 1.1v 789.755n 1.1v 794.745n 1.1v 794.755n 0.0v 799.745n 0.0v 799.755n 0.0v 804.745n 0.0v 804.755n 0.0v 809.745n 0.0v 809.755n 0.0v 814.745n 0.0v 814.755n 0.0v 819.745n 0.0v 819.755n 0.0v 824.745n 0.0v 824.755n 0.0v 829.745n 0.0v 829.755n 0.0v 834.745n 0.0v 834.755n 0.0v 839.745n 0.0v 839.755n 0.0v 844.745n 0.0v 844.755n 0.0v 849.745n 0.0v 849.755n 0.0v 854.745n 0.0v 854.755n 0.0v 859.745n 0.0v 859.755n 0.0v 864.745n 0.0v 864.755n 0.0v 869.745n 0.0v 869.755n 1.1v 874.745n 1.1v 874.755n 1.1v 879.745n 1.1v 879.755n 1.1v 884.745n 1.1v 884.755n 1.1v 889.745n 1.1v 889.755n 1.1v 894.745n 1.1v 894.755n 1.1v 899.745n 1.1v 899.755n 1.1v 904.745n 1.1v 904.755n 1.1v 909.745n 1.1v 909.755n 1.1v 914.745n 1.1v 914.755n 1.1v 919.745n 1.1v 919.755n 0.0v 924.745n 0.0v 924.755n 0.0v 929.745n 0.0v 929.755n 0.0v 934.745n 0.0v 934.755n 0.0v 939.745n 0.0v 939.755n 0.0v 944.745n 0.0v 944.755n 0.0v 949.745n 0.0v 949.755n 0.0v 954.745n 0.0v 954.755n 0.0v 959.745n 0.0v 959.755n 0.0v 964.745n 0.0v 964.755n 0.0v 969.745n 0.0v 969.755n 0.0v 974.745n 0.0v 974.755n 0.0v 979.745n 0.0v 979.755n 0.0v 984.745n 0.0v 984.755n 1.1v 989.745n 1.1v 989.755n 1.1v 994.745n 1.1v 994.755n 1.1v 999.745n 1.1v 999.755n 1.1v 1004.745n 1.1v 1004.755n 1.1v 1009.745n 1.1v 1009.755n 1.1v 1014.745n 1.1v 1014.755n 0.0v 1019.745n 0.0v 1019.755n 1.1v 1024.745n 1.1v 1024.755n 1.1v )
* (time, data): [(0, 0), (5, 0), (10, 1), (15, 1), (20, 1), (25, 1), (30, 0), (35, 1), (40, 0), (45, 0), (50, 0), (55, 0), (60, 1), (65, 1), (70, 0), (75, 0), (80, 0), (85, 0), (90, 0), (95, 0), (100, 0), (105, 0), (110, 0), (115, 1), (120, 1), (125, 0), (130, 0), (135, 0), (140, 1), (145, 1), (150, 1), (155, 1), (160, 1), (165, 1), (170, 1), (175, 1), (180, 1), (185, 1), (190, 1), (195, 1), (200, 1), (205, 1), (210, 1), (215, 1), (220, 1), (225, 1), (230, 0), (235, 0), (240, 0), (245, 0), (250, 0), (255, 1), (260, 1), (265, 1), (270, 0), (275, 0), (280, 0), (285, 0), (290, 0), (295, 0), (300, 0), (305, 0), (310, 0), (315, 0), (320, 0), (325, 1), (330, 1), (335, 1), (340, 1), (345, 0), (350, 0), (355, 0), (360, 0), (365, 0), (370, 0), (375, 0), (380, 0), (385, 1), (390, 1), (395, 1), (400, 1), (405, 1), (410, 1), (415, 1), (420, 1), (425, 1), (430, 1), (435, 1), (440, 1), (445, 1), (450, 1), (455, 1), (460, 1), (465, 1), (470, 1), (475, 1), (480, 1), (485, 1), (490, 1), (495, 1), (500, 1), (505, 1), (510, 1), (515, 1), (520, 1), (525, 1), (530, 1), (535, 1), (540, 1), (545, 1), (550, 1), (555, 0), (560, 0), (565, 0), (570, 0), (575, 0), (580, 0), (585, 0), (590, 0), (595, 0), (600, 1), (605, 1), (610, 1), (615, 1), (620, 1), (625, 1), (630, 1), (635, 1), (640, 1), (645, 1), (650, 1), (655, 1), (660, 1), (665, 1), (670, 1), (675, 1), (680, 1), (685, 1), (690, 1), (695, 1), (700, 1), (705, 1), (710, 1), (715, 0), (720, 0), (725, 0), (730, 0), (735, 0), (740, 0), (745, 0), (750, 0), (755, 0), (760, 0), (765, 0), (770, 0), (775, 0), (780, 0), (785, 0), (790, 0), (795, 1), (800, 1), (805, 1), (810, 1), (815, 1), (820, 1), (825, 1), (830, 1), (835, 1), (840, 1), (845, 1), (850, 1), (855, 1), (860, 1), (865, 1), (870, 1), (875, 1), (880, 1), (885, 1), (890, 1), (895, 0), (900, 0), (905, 0), (910, 0), (915, 0), (920, 0), (925, 0), (930, 0), (935, 0), (940, 1), (945, 1), (950, 1), (955, 1), (960, 1), (965, 1), (970, 1), (975, 1), (980, 1), (985, 1), (990, 0), (995, 0), (1000, 0), (1005, 0), (1010, 0), (1015, 1), (1020, 0), (1025, 0)]
Vdin0_8  din0_8  0 PWL (0n 0.0v 4.745n 0.0v 4.755n 0.0v 9.745n 0.0v 9.755n 1.1v 14.745n 1.1v 14.755n 1.1v 19.745n 1.1v 19.755n 1.1v 24.745n 1.1v 24.755n 1.1v 29.745n 1.1v 29.755n 0.0v 34.745n 0.0v 34.755n 1.1v 39.745n 1.1v 39.755n 0.0v 44.745n 0.0v 44.755n 0.0v 49.745n 0.0v 49.755n 0.0v 54.745n 0.0v 54.755n 0.0v 59.745n 0.0v 59.755n 1.1v 64.745n 1.1v 64.755n 1.1v 69.745n 1.1v 69.755n 0.0v 74.745n 0.0v 74.755n 0.0v 79.745n 0.0v 79.755n 0.0v 84.745n 0.0v 84.755n 0.0v 89.745n 0.0v 89.755n 0.0v 94.745n 0.0v 94.755n 0.0v 99.745n 0.0v 99.755n 0.0v 104.745n 0.0v 104.755n 0.0v 109.745n 0.0v 109.755n 0.0v 114.745n 0.0v 114.755n 1.1v 119.745n 1.1v 119.755n 1.1v 124.745n 1.1v 124.755n 0.0v 129.745n 0.0v 129.755n 0.0v 134.745n 0.0v 134.755n 0.0v 139.745n 0.0v 139.755n 1.1v 144.745n 1.1v 144.755n 1.1v 149.745n 1.1v 149.755n 1.1v 154.745n 1.1v 154.755n 1.1v 159.745n 1.1v 159.755n 1.1v 164.745n 1.1v 164.755n 1.1v 169.745n 1.1v 169.755n 1.1v 174.745n 1.1v 174.755n 1.1v 179.745n 1.1v 179.755n 1.1v 184.745n 1.1v 184.755n 1.1v 189.745n 1.1v 189.755n 1.1v 194.745n 1.1v 194.755n 1.1v 199.745n 1.1v 199.755n 1.1v 204.745n 1.1v 204.755n 1.1v 209.745n 1.1v 209.755n 1.1v 214.745n 1.1v 214.755n 1.1v 219.745n 1.1v 219.755n 1.1v 224.745n 1.1v 224.755n 1.1v 229.745n 1.1v 229.755n 0.0v 234.745n 0.0v 234.755n 0.0v 239.745n 0.0v 239.755n 0.0v 244.745n 0.0v 244.755n 0.0v 249.745n 0.0v 249.755n 0.0v 254.745n 0.0v 254.755n 1.1v 259.745n 1.1v 259.755n 1.1v 264.745n 1.1v 264.755n 1.1v 269.745n 1.1v 269.755n 0.0v 274.745n 0.0v 274.755n 0.0v 279.745n 0.0v 279.755n 0.0v 284.745n 0.0v 284.755n 0.0v 289.745n 0.0v 289.755n 0.0v 294.745n 0.0v 294.755n 0.0v 299.745n 0.0v 299.755n 0.0v 304.745n 0.0v 304.755n 0.0v 309.745n 0.0v 309.755n 0.0v 314.745n 0.0v 314.755n 0.0v 319.745n 0.0v 319.755n 0.0v 324.745n 0.0v 324.755n 1.1v 329.745n 1.1v 329.755n 1.1v 334.745n 1.1v 334.755n 1.1v 339.745n 1.1v 339.755n 1.1v 344.745n 1.1v 344.755n 0.0v 349.745n 0.0v 349.755n 0.0v 354.745n 0.0v 354.755n 0.0v 359.745n 0.0v 359.755n 0.0v 364.745n 0.0v 364.755n 0.0v 369.745n 0.0v 369.755n 0.0v 374.745n 0.0v 374.755n 0.0v 379.745n 0.0v 379.755n 0.0v 384.745n 0.0v 384.755n 1.1v 389.745n 1.1v 389.755n 1.1v 394.745n 1.1v 394.755n 1.1v 399.745n 1.1v 399.755n 1.1v 404.745n 1.1v 404.755n 1.1v 409.745n 1.1v 409.755n 1.1v 414.745n 1.1v 414.755n 1.1v 419.745n 1.1v 419.755n 1.1v 424.745n 1.1v 424.755n 1.1v 429.745n 1.1v 429.755n 1.1v 434.745n 1.1v 434.755n 1.1v 439.745n 1.1v 439.755n 1.1v 444.745n 1.1v 444.755n 1.1v 449.745n 1.1v 449.755n 1.1v 454.745n 1.1v 454.755n 1.1v 459.745n 1.1v 459.755n 1.1v 464.745n 1.1v 464.755n 1.1v 469.745n 1.1v 469.755n 1.1v 474.745n 1.1v 474.755n 1.1v 479.745n 1.1v 479.755n 1.1v 484.745n 1.1v 484.755n 1.1v 489.745n 1.1v 489.755n 1.1v 494.745n 1.1v 494.755n 1.1v 499.745n 1.1v 499.755n 1.1v 504.745n 1.1v 504.755n 1.1v 509.745n 1.1v 509.755n 1.1v 514.745n 1.1v 514.755n 1.1v 519.745n 1.1v 519.755n 1.1v 524.745n 1.1v 524.755n 1.1v 529.745n 1.1v 529.755n 1.1v 534.745n 1.1v 534.755n 1.1v 539.745n 1.1v 539.755n 1.1v 544.745n 1.1v 544.755n 1.1v 549.745n 1.1v 549.755n 1.1v 554.745n 1.1v 554.755n 0.0v 559.745n 0.0v 559.755n 0.0v 564.745n 0.0v 564.755n 0.0v 569.745n 0.0v 569.755n 0.0v 574.745n 0.0v 574.755n 0.0v 579.745n 0.0v 579.755n 0.0v 584.745n 0.0v 584.755n 0.0v 589.745n 0.0v 589.755n 0.0v 594.745n 0.0v 594.755n 0.0v 599.745n 0.0v 599.755n 1.1v 604.745n 1.1v 604.755n 1.1v 609.745n 1.1v 609.755n 1.1v 614.745n 1.1v 614.755n 1.1v 619.745n 1.1v 619.755n 1.1v 624.745n 1.1v 624.755n 1.1v 629.745n 1.1v 629.755n 1.1v 634.745n 1.1v 634.755n 1.1v 639.745n 1.1v 639.755n 1.1v 644.745n 1.1v 644.755n 1.1v 649.745n 1.1v 649.755n 1.1v 654.745n 1.1v 654.755n 1.1v 659.745n 1.1v 659.755n 1.1v 664.745n 1.1v 664.755n 1.1v 669.745n 1.1v 669.755n 1.1v 674.745n 1.1v 674.755n 1.1v 679.745n 1.1v 679.755n 1.1v 684.745n 1.1v 684.755n 1.1v 689.745n 1.1v 689.755n 1.1v 694.745n 1.1v 694.755n 1.1v 699.745n 1.1v 699.755n 1.1v 704.745n 1.1v 704.755n 1.1v 709.745n 1.1v 709.755n 1.1v 714.745n 1.1v 714.755n 0.0v 719.745n 0.0v 719.755n 0.0v 724.745n 0.0v 724.755n 0.0v 729.745n 0.0v 729.755n 0.0v 734.745n 0.0v 734.755n 0.0v 739.745n 0.0v 739.755n 0.0v 744.745n 0.0v 744.755n 0.0v 749.745n 0.0v 749.755n 0.0v 754.745n 0.0v 754.755n 0.0v 759.745n 0.0v 759.755n 0.0v 764.745n 0.0v 764.755n 0.0v 769.745n 0.0v 769.755n 0.0v 774.745n 0.0v 774.755n 0.0v 779.745n 0.0v 779.755n 0.0v 784.745n 0.0v 784.755n 0.0v 789.745n 0.0v 789.755n 0.0v 794.745n 0.0v 794.755n 1.1v 799.745n 1.1v 799.755n 1.1v 804.745n 1.1v 804.755n 1.1v 809.745n 1.1v 809.755n 1.1v 814.745n 1.1v 814.755n 1.1v 819.745n 1.1v 819.755n 1.1v 824.745n 1.1v 824.755n 1.1v 829.745n 1.1v 829.755n 1.1v 834.745n 1.1v 834.755n 1.1v 839.745n 1.1v 839.755n 1.1v 844.745n 1.1v 844.755n 1.1v 849.745n 1.1v 849.755n 1.1v 854.745n 1.1v 854.755n 1.1v 859.745n 1.1v 859.755n 1.1v 864.745n 1.1v 864.755n 1.1v 869.745n 1.1v 869.755n 1.1v 874.745n 1.1v 874.755n 1.1v 879.745n 1.1v 879.755n 1.1v 884.745n 1.1v 884.755n 1.1v 889.745n 1.1v 889.755n 1.1v 894.745n 1.1v 894.755n 0.0v 899.745n 0.0v 899.755n 0.0v 904.745n 0.0v 904.755n 0.0v 909.745n 0.0v 909.755n 0.0v 914.745n 0.0v 914.755n 0.0v 919.745n 0.0v 919.755n 0.0v 924.745n 0.0v 924.755n 0.0v 929.745n 0.0v 929.755n 0.0v 934.745n 0.0v 934.755n 0.0v 939.745n 0.0v 939.755n 1.1v 944.745n 1.1v 944.755n 1.1v 949.745n 1.1v 949.755n 1.1v 954.745n 1.1v 954.755n 1.1v 959.745n 1.1v 959.755n 1.1v 964.745n 1.1v 964.755n 1.1v 969.745n 1.1v 969.755n 1.1v 974.745n 1.1v 974.755n 1.1v 979.745n 1.1v 979.755n 1.1v 984.745n 1.1v 984.755n 1.1v 989.745n 1.1v 989.755n 0.0v 994.745n 0.0v 994.755n 0.0v 999.745n 0.0v 999.755n 0.0v 1004.745n 0.0v 1004.755n 0.0v 1009.745n 0.0v 1009.755n 0.0v 1014.745n 0.0v 1014.755n 1.1v 1019.745n 1.1v 1019.755n 0.0v 1024.745n 0.0v 1024.755n 0.0v )
* (time, data): [(0, 0), (5, 0), (10, 1), (15, 0), (20, 0), (25, 0), (30, 0), (35, 1), (40, 1), (45, 1), (50, 1), (55, 1), (60, 0), (65, 0), (70, 1), (75, 1), (80, 1), (85, 1), (90, 1), (95, 1), (100, 0), (105, 0), (110, 0), (115, 0), (120, 0), (125, 1), (130, 1), (135, 1), (140, 0), (145, 0), (150, 0), (155, 0), (160, 0), (165, 1), (170, 1), (175, 1), (180, 1), (185, 1), (190, 1), (195, 1), (200, 1), (205, 1), (210, 1), (215, 1), (220, 1), (225, 1), (230, 0), (235, 0), (240, 0), (245, 0), (250, 0), (255, 1), (260, 1), (265, 1), (270, 0), (275, 0), (280, 0), (285, 1), (290, 1), (295, 1), (300, 1), (305, 1), (310, 1), (315, 1), (320, 1), (325, 0), (330, 0), (335, 0), (340, 0), (345, 0), (350, 0), (355, 0), (360, 0), (365, 0), (370, 1), (375, 0), (380, 0), (385, 0), (390, 0), (395, 0), (400, 0), (405, 0), (410, 0), (415, 0), (420, 1), (425, 1), (430, 0), (435, 0), (440, 0), (445, 0), (450, 0), (455, 0), (460, 0), (465, 0), (470, 0), (475, 0), (480, 1), (485, 0), (490, 0), (495, 1), (500, 1), (505, 1), (510, 1), (515, 1), (520, 0), (525, 0), (530, 0), (535, 1), (540, 0), (545, 0), (550, 0), (555, 0), (560, 0), (565, 0), (570, 0), (575, 0), (580, 0), (585, 0), (590, 0), (595, 0), (600, 0), (605, 0), (610, 0), (615, 0), (620, 1), (625, 1), (630, 1), (635, 1), (640, 1), (645, 1), (650, 1), (655, 0), (660, 0), (665, 0), (670, 0), (675, 0), (680, 0), (685, 0), (690, 1), (695, 1), (700, 1), (705, 1), (710, 1), (715, 0), (720, 0), (725, 0), (730, 0), (735, 0), (740, 0), (745, 0), (750, 0), (755, 0), (760, 0), (765, 0), (770, 0), (775, 0), (780, 0), (785, 0), (790, 0), (795, 0), (800, 0), (805, 0), (810, 0), (815, 0), (820, 0), (825, 0), (830, 0), (835, 0), (840, 1), (845, 1), (850, 1), (855, 1), (860, 1), (865, 1), (870, 1), (875, 1), (880, 1), (885, 1), (890, 1), (895, 0), (900, 0), (905, 0), (910, 0), (915, 0), (920, 1), (925, 1), (930, 1), (935, 1), (940, 0), (945, 0), (950, 0), (955, 0), (960, 0), (965, 0), (970, 0), (975, 0), (980, 0), (985, 0), (990, 0), (995, 0), (1000, 0), (1005, 0), (1010, 0), (1015, 0), (1020, 1), (1025, 1)]
Vdin0_9  din0_9  0 PWL (0n 0.0v 4.745n 0.0v 4.755n 0.0v 9.745n 0.0v 9.755n 1.1v 14.745n 1.1v 14.755n 0.0v 19.745n 0.0v 19.755n 0.0v 24.745n 0.0v 24.755n 0.0v 29.745n 0.0v 29.755n 0.0v 34.745n 0.0v 34.755n 1.1v 39.745n 1.1v 39.755n 1.1v 44.745n 1.1v 44.755n 1.1v 49.745n 1.1v 49.755n 1.1v 54.745n 1.1v 54.755n 1.1v 59.745n 1.1v 59.755n 0.0v 64.745n 0.0v 64.755n 0.0v 69.745n 0.0v 69.755n 1.1v 74.745n 1.1v 74.755n 1.1v 79.745n 1.1v 79.755n 1.1v 84.745n 1.1v 84.755n 1.1v 89.745n 1.1v 89.755n 1.1v 94.745n 1.1v 94.755n 1.1v 99.745n 1.1v 99.755n 0.0v 104.745n 0.0v 104.755n 0.0v 109.745n 0.0v 109.755n 0.0v 114.745n 0.0v 114.755n 0.0v 119.745n 0.0v 119.755n 0.0v 124.745n 0.0v 124.755n 1.1v 129.745n 1.1v 129.755n 1.1v 134.745n 1.1v 134.755n 1.1v 139.745n 1.1v 139.755n 0.0v 144.745n 0.0v 144.755n 0.0v 149.745n 0.0v 149.755n 0.0v 154.745n 0.0v 154.755n 0.0v 159.745n 0.0v 159.755n 0.0v 164.745n 0.0v 164.755n 1.1v 169.745n 1.1v 169.755n 1.1v 174.745n 1.1v 174.755n 1.1v 179.745n 1.1v 179.755n 1.1v 184.745n 1.1v 184.755n 1.1v 189.745n 1.1v 189.755n 1.1v 194.745n 1.1v 194.755n 1.1v 199.745n 1.1v 199.755n 1.1v 204.745n 1.1v 204.755n 1.1v 209.745n 1.1v 209.755n 1.1v 214.745n 1.1v 214.755n 1.1v 219.745n 1.1v 219.755n 1.1v 224.745n 1.1v 224.755n 1.1v 229.745n 1.1v 229.755n 0.0v 234.745n 0.0v 234.755n 0.0v 239.745n 0.0v 239.755n 0.0v 244.745n 0.0v 244.755n 0.0v 249.745n 0.0v 249.755n 0.0v 254.745n 0.0v 254.755n 1.1v 259.745n 1.1v 259.755n 1.1v 264.745n 1.1v 264.755n 1.1v 269.745n 1.1v 269.755n 0.0v 274.745n 0.0v 274.755n 0.0v 279.745n 0.0v 279.755n 0.0v 284.745n 0.0v 284.755n 1.1v 289.745n 1.1v 289.755n 1.1v 294.745n 1.1v 294.755n 1.1v 299.745n 1.1v 299.755n 1.1v 304.745n 1.1v 304.755n 1.1v 309.745n 1.1v 309.755n 1.1v 314.745n 1.1v 314.755n 1.1v 319.745n 1.1v 319.755n 1.1v 324.745n 1.1v 324.755n 0.0v 329.745n 0.0v 329.755n 0.0v 334.745n 0.0v 334.755n 0.0v 339.745n 0.0v 339.755n 0.0v 344.745n 0.0v 344.755n 0.0v 349.745n 0.0v 349.755n 0.0v 354.745n 0.0v 354.755n 0.0v 359.745n 0.0v 359.755n 0.0v 364.745n 0.0v 364.755n 0.0v 369.745n 0.0v 369.755n 1.1v 374.745n 1.1v 374.755n 0.0v 379.745n 0.0v 379.755n 0.0v 384.745n 0.0v 384.755n 0.0v 389.745n 0.0v 389.755n 0.0v 394.745n 0.0v 394.755n 0.0v 399.745n 0.0v 399.755n 0.0v 404.745n 0.0v 404.755n 0.0v 409.745n 0.0v 409.755n 0.0v 414.745n 0.0v 414.755n 0.0v 419.745n 0.0v 419.755n 1.1v 424.745n 1.1v 424.755n 1.1v 429.745n 1.1v 429.755n 0.0v 434.745n 0.0v 434.755n 0.0v 439.745n 0.0v 439.755n 0.0v 444.745n 0.0v 444.755n 0.0v 449.745n 0.0v 449.755n 0.0v 454.745n 0.0v 454.755n 0.0v 459.745n 0.0v 459.755n 0.0v 464.745n 0.0v 464.755n 0.0v 469.745n 0.0v 469.755n 0.0v 474.745n 0.0v 474.755n 0.0v 479.745n 0.0v 479.755n 1.1v 484.745n 1.1v 484.755n 0.0v 489.745n 0.0v 489.755n 0.0v 494.745n 0.0v 494.755n 1.1v 499.745n 1.1v 499.755n 1.1v 504.745n 1.1v 504.755n 1.1v 509.745n 1.1v 509.755n 1.1v 514.745n 1.1v 514.755n 1.1v 519.745n 1.1v 519.755n 0.0v 524.745n 0.0v 524.755n 0.0v 529.745n 0.0v 529.755n 0.0v 534.745n 0.0v 534.755n 1.1v 539.745n 1.1v 539.755n 0.0v 544.745n 0.0v 544.755n 0.0v 549.745n 0.0v 549.755n 0.0v 554.745n 0.0v 554.755n 0.0v 559.745n 0.0v 559.755n 0.0v 564.745n 0.0v 564.755n 0.0v 569.745n 0.0v 569.755n 0.0v 574.745n 0.0v 574.755n 0.0v 579.745n 0.0v 579.755n 0.0v 584.745n 0.0v 584.755n 0.0v 589.745n 0.0v 589.755n 0.0v 594.745n 0.0v 594.755n 0.0v 599.745n 0.0v 599.755n 0.0v 604.745n 0.0v 604.755n 0.0v 609.745n 0.0v 609.755n 0.0v 614.745n 0.0v 614.755n 0.0v 619.745n 0.0v 619.755n 1.1v 624.745n 1.1v 624.755n 1.1v 629.745n 1.1v 629.755n 1.1v 634.745n 1.1v 634.755n 1.1v 639.745n 1.1v 639.755n 1.1v 644.745n 1.1v 644.755n 1.1v 649.745n 1.1v 649.755n 1.1v 654.745n 1.1v 654.755n 0.0v 659.745n 0.0v 659.755n 0.0v 664.745n 0.0v 664.755n 0.0v 669.745n 0.0v 669.755n 0.0v 674.745n 0.0v 674.755n 0.0v 679.745n 0.0v 679.755n 0.0v 684.745n 0.0v 684.755n 0.0v 689.745n 0.0v 689.755n 1.1v 694.745n 1.1v 694.755n 1.1v 699.745n 1.1v 699.755n 1.1v 704.745n 1.1v 704.755n 1.1v 709.745n 1.1v 709.755n 1.1v 714.745n 1.1v 714.755n 0.0v 719.745n 0.0v 719.755n 0.0v 724.745n 0.0v 724.755n 0.0v 729.745n 0.0v 729.755n 0.0v 734.745n 0.0v 734.755n 0.0v 739.745n 0.0v 739.755n 0.0v 744.745n 0.0v 744.755n 0.0v 749.745n 0.0v 749.755n 0.0v 754.745n 0.0v 754.755n 0.0v 759.745n 0.0v 759.755n 0.0v 764.745n 0.0v 764.755n 0.0v 769.745n 0.0v 769.755n 0.0v 774.745n 0.0v 774.755n 0.0v 779.745n 0.0v 779.755n 0.0v 784.745n 0.0v 784.755n 0.0v 789.745n 0.0v 789.755n 0.0v 794.745n 0.0v 794.755n 0.0v 799.745n 0.0v 799.755n 0.0v 804.745n 0.0v 804.755n 0.0v 809.745n 0.0v 809.755n 0.0v 814.745n 0.0v 814.755n 0.0v 819.745n 0.0v 819.755n 0.0v 824.745n 0.0v 824.755n 0.0v 829.745n 0.0v 829.755n 0.0v 834.745n 0.0v 834.755n 0.0v 839.745n 0.0v 839.755n 1.1v 844.745n 1.1v 844.755n 1.1v 849.745n 1.1v 849.755n 1.1v 854.745n 1.1v 854.755n 1.1v 859.745n 1.1v 859.755n 1.1v 864.745n 1.1v 864.755n 1.1v 869.745n 1.1v 869.755n 1.1v 874.745n 1.1v 874.755n 1.1v 879.745n 1.1v 879.755n 1.1v 884.745n 1.1v 884.755n 1.1v 889.745n 1.1v 889.755n 1.1v 894.745n 1.1v 894.755n 0.0v 899.745n 0.0v 899.755n 0.0v 904.745n 0.0v 904.755n 0.0v 909.745n 0.0v 909.755n 0.0v 914.745n 0.0v 914.755n 0.0v 919.745n 0.0v 919.755n 1.1v 924.745n 1.1v 924.755n 1.1v 929.745n 1.1v 929.755n 1.1v 934.745n 1.1v 934.755n 1.1v 939.745n 1.1v 939.755n 0.0v 944.745n 0.0v 944.755n 0.0v 949.745n 0.0v 949.755n 0.0v 954.745n 0.0v 954.755n 0.0v 959.745n 0.0v 959.755n 0.0v 964.745n 0.0v 964.755n 0.0v 969.745n 0.0v 969.755n 0.0v 974.745n 0.0v 974.755n 0.0v 979.745n 0.0v 979.755n 0.0v 984.745n 0.0v 984.755n 0.0v 989.745n 0.0v 989.755n 0.0v 994.745n 0.0v 994.755n 0.0v 999.745n 0.0v 999.755n 0.0v 1004.745n 0.0v 1004.755n 0.0v 1009.745n 0.0v 1009.755n 0.0v 1014.745n 0.0v 1014.755n 0.0v 1019.745n 0.0v 1019.755n 1.1v 1024.745n 1.1v 1024.755n 1.1v )
* (time, data): [(0, 0), (5, 1), (10, 1), (15, 1), (20, 1), (25, 1), (30, 1), (35, 1), (40, 1), (45, 1), (50, 1), (55, 1), (60, 0), (65, 0), (70, 1), (75, 1), (80, 1), (85, 1), (90, 1), (95, 1), (100, 0), (105, 0), (110, 0), (115, 1), (120, 1), (125, 1), (130, 1), (135, 1), (140, 1), (145, 0), (150, 0), (155, 0), (160, 0), (165, 0), (170, 0), (175, 0), (180, 0), (185, 0), (190, 0), (195, 0), (200, 1), (205, 1), (210, 1), (215, 1), (220, 0), (225, 0), (230, 0), (235, 0), (240, 0), (245, 0), (250, 0), (255, 1), (260, 1), (265, 1), (270, 1), (275, 1), (280, 1), (285, 0), (290, 0), (295, 0), (300, 0), (305, 1), (310, 1), (315, 1), (320, 1), (325, 1), (330, 1), (335, 1), (340, 1), (345, 1), (350, 1), (355, 1), (360, 1), (365, 1), (370, 1), (375, 1), (380, 1), (385, 0), (390, 0), (395, 0), (400, 0), (405, 0), (410, 0), (415, 1), (420, 0), (425, 0), (430, 0), (435, 0), (440, 0), (445, 0), (450, 0), (455, 0), (460, 0), (465, 0), (470, 0), (475, 0), (480, 1), (485, 0), (490, 0), (495, 1), (500, 1), (505, 1), (510, 1), (515, 1), (520, 1), (525, 1), (530, 1), (535, 0), (540, 0), (545, 0), (550, 0), (555, 1), (560, 1), (565, 1), (570, 1), (575, 1), (580, 1), (585, 1), (590, 1), (595, 1), (600, 1), (605, 1), (610, 1), (615, 1), (620, 1), (625, 1), (630, 1), (635, 1), (640, 1), (645, 1), (650, 1), (655, 0), (660, 0), (665, 0), (670, 0), (675, 0), (680, 0), (685, 0), (690, 0), (695, 0), (700, 0), (705, 0), (710, 0), (715, 1), (720, 1), (725, 0), (730, 0), (735, 0), (740, 0), (745, 0), (750, 0), (755, 0), (760, 0), (765, 0), (770, 0), (775, 0), (780, 0), (785, 0), (790, 0), (795, 1), (800, 1), (805, 1), (810, 1), (815, 1), (820, 1), (825, 1), (830, 1), (835, 1), (840, 1), (845, 1), (850, 1), (855, 1), (860, 1), (865, 1), (870, 0), (875, 0), (880, 0), (885, 0), (890, 0), (895, 1), (900, 1), (905, 1), (910, 1), (915, 1), (920, 1), (925, 1), (930, 1), (935, 1), (940, 1), (945, 1), (950, 1), (955, 1), (960, 1), (965, 1), (970, 1), (975, 1), (980, 1), (985, 0), (990, 0), (995, 0), (1000, 0), (1005, 0), (1010, 0), (1015, 0), (1020, 0), (1025, 0)]
Vdin0_10  din0_10  0 PWL (0n 0.0v 4.745n 0.0v 4.755n 1.1v 9.745n 1.1v 9.755n 1.1v 14.745n 1.1v 14.755n 1.1v 19.745n 1.1v 19.755n 1.1v 24.745n 1.1v 24.755n 1.1v 29.745n 1.1v 29.755n 1.1v 34.745n 1.1v 34.755n 1.1v 39.745n 1.1v 39.755n 1.1v 44.745n 1.1v 44.755n 1.1v 49.745n 1.1v 49.755n 1.1v 54.745n 1.1v 54.755n 1.1v 59.745n 1.1v 59.755n 0.0v 64.745n 0.0v 64.755n 0.0v 69.745n 0.0v 69.755n 1.1v 74.745n 1.1v 74.755n 1.1v 79.745n 1.1v 79.755n 1.1v 84.745n 1.1v 84.755n 1.1v 89.745n 1.1v 89.755n 1.1v 94.745n 1.1v 94.755n 1.1v 99.745n 1.1v 99.755n 0.0v 104.745n 0.0v 104.755n 0.0v 109.745n 0.0v 109.755n 0.0v 114.745n 0.0v 114.755n 1.1v 119.745n 1.1v 119.755n 1.1v 124.745n 1.1v 124.755n 1.1v 129.745n 1.1v 129.755n 1.1v 134.745n 1.1v 134.755n 1.1v 139.745n 1.1v 139.755n 1.1v 144.745n 1.1v 144.755n 0.0v 149.745n 0.0v 149.755n 0.0v 154.745n 0.0v 154.755n 0.0v 159.745n 0.0v 159.755n 0.0v 164.745n 0.0v 164.755n 0.0v 169.745n 0.0v 169.755n 0.0v 174.745n 0.0v 174.755n 0.0v 179.745n 0.0v 179.755n 0.0v 184.745n 0.0v 184.755n 0.0v 189.745n 0.0v 189.755n 0.0v 194.745n 0.0v 194.755n 0.0v 199.745n 0.0v 199.755n 1.1v 204.745n 1.1v 204.755n 1.1v 209.745n 1.1v 209.755n 1.1v 214.745n 1.1v 214.755n 1.1v 219.745n 1.1v 219.755n 0.0v 224.745n 0.0v 224.755n 0.0v 229.745n 0.0v 229.755n 0.0v 234.745n 0.0v 234.755n 0.0v 239.745n 0.0v 239.755n 0.0v 244.745n 0.0v 244.755n 0.0v 249.745n 0.0v 249.755n 0.0v 254.745n 0.0v 254.755n 1.1v 259.745n 1.1v 259.755n 1.1v 264.745n 1.1v 264.755n 1.1v 269.745n 1.1v 269.755n 1.1v 274.745n 1.1v 274.755n 1.1v 279.745n 1.1v 279.755n 1.1v 284.745n 1.1v 284.755n 0.0v 289.745n 0.0v 289.755n 0.0v 294.745n 0.0v 294.755n 0.0v 299.745n 0.0v 299.755n 0.0v 304.745n 0.0v 304.755n 1.1v 309.745n 1.1v 309.755n 1.1v 314.745n 1.1v 314.755n 1.1v 319.745n 1.1v 319.755n 1.1v 324.745n 1.1v 324.755n 1.1v 329.745n 1.1v 329.755n 1.1v 334.745n 1.1v 334.755n 1.1v 339.745n 1.1v 339.755n 1.1v 344.745n 1.1v 344.755n 1.1v 349.745n 1.1v 349.755n 1.1v 354.745n 1.1v 354.755n 1.1v 359.745n 1.1v 359.755n 1.1v 364.745n 1.1v 364.755n 1.1v 369.745n 1.1v 369.755n 1.1v 374.745n 1.1v 374.755n 1.1v 379.745n 1.1v 379.755n 1.1v 384.745n 1.1v 384.755n 0.0v 389.745n 0.0v 389.755n 0.0v 394.745n 0.0v 394.755n 0.0v 399.745n 0.0v 399.755n 0.0v 404.745n 0.0v 404.755n 0.0v 409.745n 0.0v 409.755n 0.0v 414.745n 0.0v 414.755n 1.1v 419.745n 1.1v 419.755n 0.0v 424.745n 0.0v 424.755n 0.0v 429.745n 0.0v 429.755n 0.0v 434.745n 0.0v 434.755n 0.0v 439.745n 0.0v 439.755n 0.0v 444.745n 0.0v 444.755n 0.0v 449.745n 0.0v 449.755n 0.0v 454.745n 0.0v 454.755n 0.0v 459.745n 0.0v 459.755n 0.0v 464.745n 0.0v 464.755n 0.0v 469.745n 0.0v 469.755n 0.0v 474.745n 0.0v 474.755n 0.0v 479.745n 0.0v 479.755n 1.1v 484.745n 1.1v 484.755n 0.0v 489.745n 0.0v 489.755n 0.0v 494.745n 0.0v 494.755n 1.1v 499.745n 1.1v 499.755n 1.1v 504.745n 1.1v 504.755n 1.1v 509.745n 1.1v 509.755n 1.1v 514.745n 1.1v 514.755n 1.1v 519.745n 1.1v 519.755n 1.1v 524.745n 1.1v 524.755n 1.1v 529.745n 1.1v 529.755n 1.1v 534.745n 1.1v 534.755n 0.0v 539.745n 0.0v 539.755n 0.0v 544.745n 0.0v 544.755n 0.0v 549.745n 0.0v 549.755n 0.0v 554.745n 0.0v 554.755n 1.1v 559.745n 1.1v 559.755n 1.1v 564.745n 1.1v 564.755n 1.1v 569.745n 1.1v 569.755n 1.1v 574.745n 1.1v 574.755n 1.1v 579.745n 1.1v 579.755n 1.1v 584.745n 1.1v 584.755n 1.1v 589.745n 1.1v 589.755n 1.1v 594.745n 1.1v 594.755n 1.1v 599.745n 1.1v 599.755n 1.1v 604.745n 1.1v 604.755n 1.1v 609.745n 1.1v 609.755n 1.1v 614.745n 1.1v 614.755n 1.1v 619.745n 1.1v 619.755n 1.1v 624.745n 1.1v 624.755n 1.1v 629.745n 1.1v 629.755n 1.1v 634.745n 1.1v 634.755n 1.1v 639.745n 1.1v 639.755n 1.1v 644.745n 1.1v 644.755n 1.1v 649.745n 1.1v 649.755n 1.1v 654.745n 1.1v 654.755n 0.0v 659.745n 0.0v 659.755n 0.0v 664.745n 0.0v 664.755n 0.0v 669.745n 0.0v 669.755n 0.0v 674.745n 0.0v 674.755n 0.0v 679.745n 0.0v 679.755n 0.0v 684.745n 0.0v 684.755n 0.0v 689.745n 0.0v 689.755n 0.0v 694.745n 0.0v 694.755n 0.0v 699.745n 0.0v 699.755n 0.0v 704.745n 0.0v 704.755n 0.0v 709.745n 0.0v 709.755n 0.0v 714.745n 0.0v 714.755n 1.1v 719.745n 1.1v 719.755n 1.1v 724.745n 1.1v 724.755n 0.0v 729.745n 0.0v 729.755n 0.0v 734.745n 0.0v 734.755n 0.0v 739.745n 0.0v 739.755n 0.0v 744.745n 0.0v 744.755n 0.0v 749.745n 0.0v 749.755n 0.0v 754.745n 0.0v 754.755n 0.0v 759.745n 0.0v 759.755n 0.0v 764.745n 0.0v 764.755n 0.0v 769.745n 0.0v 769.755n 0.0v 774.745n 0.0v 774.755n 0.0v 779.745n 0.0v 779.755n 0.0v 784.745n 0.0v 784.755n 0.0v 789.745n 0.0v 789.755n 0.0v 794.745n 0.0v 794.755n 1.1v 799.745n 1.1v 799.755n 1.1v 804.745n 1.1v 804.755n 1.1v 809.745n 1.1v 809.755n 1.1v 814.745n 1.1v 814.755n 1.1v 819.745n 1.1v 819.755n 1.1v 824.745n 1.1v 824.755n 1.1v 829.745n 1.1v 829.755n 1.1v 834.745n 1.1v 834.755n 1.1v 839.745n 1.1v 839.755n 1.1v 844.745n 1.1v 844.755n 1.1v 849.745n 1.1v 849.755n 1.1v 854.745n 1.1v 854.755n 1.1v 859.745n 1.1v 859.755n 1.1v 864.745n 1.1v 864.755n 1.1v 869.745n 1.1v 869.755n 0.0v 874.745n 0.0v 874.755n 0.0v 879.745n 0.0v 879.755n 0.0v 884.745n 0.0v 884.755n 0.0v 889.745n 0.0v 889.755n 0.0v 894.745n 0.0v 894.755n 1.1v 899.745n 1.1v 899.755n 1.1v 904.745n 1.1v 904.755n 1.1v 909.745n 1.1v 909.755n 1.1v 914.745n 1.1v 914.755n 1.1v 919.745n 1.1v 919.755n 1.1v 924.745n 1.1v 924.755n 1.1v 929.745n 1.1v 929.755n 1.1v 934.745n 1.1v 934.755n 1.1v 939.745n 1.1v 939.755n 1.1v 944.745n 1.1v 944.755n 1.1v 949.745n 1.1v 949.755n 1.1v 954.745n 1.1v 954.755n 1.1v 959.745n 1.1v 959.755n 1.1v 964.745n 1.1v 964.755n 1.1v 969.745n 1.1v 969.755n 1.1v 974.745n 1.1v 974.755n 1.1v 979.745n 1.1v 979.755n 1.1v 984.745n 1.1v 984.755n 0.0v 989.745n 0.0v 989.755n 0.0v 994.745n 0.0v 994.755n 0.0v 999.745n 0.0v 999.755n 0.0v 1004.745n 0.0v 1004.755n 0.0v 1009.745n 0.0v 1009.755n 0.0v 1014.745n 0.0v 1014.755n 0.0v 1019.745n 0.0v 1019.755n 0.0v 1024.745n 0.0v 1024.755n 0.0v )
* (time, data): [(0, 0), (5, 0), (10, 1), (15, 1), (20, 1), (25, 1), (30, 0), (35, 0), (40, 0), (45, 0), (50, 0), (55, 0), (60, 0), (65, 0), (70, 1), (75, 1), (80, 1), (85, 1), (90, 1), (95, 1), (100, 1), (105, 1), (110, 1), (115, 0), (120, 0), (125, 0), (130, 0), (135, 0), (140, 0), (145, 1), (150, 1), (155, 1), (160, 1), (165, 1), (170, 1), (175, 1), (180, 1), (185, 1), (190, 1), (195, 1), (200, 0), (205, 0), (210, 0), (215, 0), (220, 0), (225, 0), (230, 1), (235, 1), (240, 1), (245, 1), (250, 1), (255, 1), (260, 1), (265, 1), (270, 1), (275, 1), (280, 1), (285, 0), (290, 0), (295, 0), (300, 0), (305, 1), (310, 1), (315, 1), (320, 1), (325, 1), (330, 0), (335, 0), (340, 0), (345, 1), (350, 1), (355, 1), (360, 1), (365, 1), (370, 0), (375, 1), (380, 1), (385, 0), (390, 0), (395, 0), (400, 0), (405, 0), (410, 0), (415, 1), (420, 0), (425, 0), (430, 1), (435, 1), (440, 1), (445, 1), (450, 1), (455, 1), (460, 1), (465, 1), (470, 1), (475, 1), (480, 0), (485, 1), (490, 1), (495, 0), (500, 0), (505, 0), (510, 0), (515, 0), (520, 0), (525, 0), (530, 0), (535, 1), (540, 0), (545, 0), (550, 0), (555, 0), (560, 0), (565, 0), (570, 1), (575, 1), (580, 1), (585, 0), (590, 0), (595, 0), (600, 1), (605, 1), (610, 1), (615, 1), (620, 1), (625, 1), (630, 1), (635, 1), (640, 1), (645, 1), (650, 1), (655, 1), (660, 1), (665, 1), (670, 1), (675, 1), (680, 1), (685, 1), (690, 1), (695, 1), (700, 1), (705, 1), (710, 1), (715, 1), (720, 1), (725, 0), (730, 0), (735, 0), (740, 0), (745, 0), (750, 0), (755, 0), (760, 0), (765, 0), (770, 0), (775, 0), (780, 0), (785, 0), (790, 0), (795, 1), (800, 1), (805, 1), (810, 1), (815, 1), (820, 1), (825, 1), (830, 1), (835, 1), (840, 0), (845, 0), (850, 0), (855, 0), (860, 0), (865, 0), (870, 1), (875, 1), (880, 1), (885, 1), (890, 1), (895, 0), (900, 0), (905, 0), (910, 0), (915, 0), (920, 0), (925, 0), (930, 0), (935, 0), (940, 1), (945, 1), (950, 1), (955, 1), (960, 1), (965, 1), (970, 1), (975, 1), (980, 1), (985, 0), (990, 0), (995, 0), (1000, 0), (1005, 0), (1010, 0), (1015, 0), (1020, 0), (1025, 0)]
Vdin0_11  din0_11  0 PWL (0n 0.0v 4.745n 0.0v 4.755n 0.0v 9.745n 0.0v 9.755n 1.1v 14.745n 1.1v 14.755n 1.1v 19.745n 1.1v 19.755n 1.1v 24.745n 1.1v 24.755n 1.1v 29.745n 1.1v 29.755n 0.0v 34.745n 0.0v 34.755n 0.0v 39.745n 0.0v 39.755n 0.0v 44.745n 0.0v 44.755n 0.0v 49.745n 0.0v 49.755n 0.0v 54.745n 0.0v 54.755n 0.0v 59.745n 0.0v 59.755n 0.0v 64.745n 0.0v 64.755n 0.0v 69.745n 0.0v 69.755n 1.1v 74.745n 1.1v 74.755n 1.1v 79.745n 1.1v 79.755n 1.1v 84.745n 1.1v 84.755n 1.1v 89.745n 1.1v 89.755n 1.1v 94.745n 1.1v 94.755n 1.1v 99.745n 1.1v 99.755n 1.1v 104.745n 1.1v 104.755n 1.1v 109.745n 1.1v 109.755n 1.1v 114.745n 1.1v 114.755n 0.0v 119.745n 0.0v 119.755n 0.0v 124.745n 0.0v 124.755n 0.0v 129.745n 0.0v 129.755n 0.0v 134.745n 0.0v 134.755n 0.0v 139.745n 0.0v 139.755n 0.0v 144.745n 0.0v 144.755n 1.1v 149.745n 1.1v 149.755n 1.1v 154.745n 1.1v 154.755n 1.1v 159.745n 1.1v 159.755n 1.1v 164.745n 1.1v 164.755n 1.1v 169.745n 1.1v 169.755n 1.1v 174.745n 1.1v 174.755n 1.1v 179.745n 1.1v 179.755n 1.1v 184.745n 1.1v 184.755n 1.1v 189.745n 1.1v 189.755n 1.1v 194.745n 1.1v 194.755n 1.1v 199.745n 1.1v 199.755n 0.0v 204.745n 0.0v 204.755n 0.0v 209.745n 0.0v 209.755n 0.0v 214.745n 0.0v 214.755n 0.0v 219.745n 0.0v 219.755n 0.0v 224.745n 0.0v 224.755n 0.0v 229.745n 0.0v 229.755n 1.1v 234.745n 1.1v 234.755n 1.1v 239.745n 1.1v 239.755n 1.1v 244.745n 1.1v 244.755n 1.1v 249.745n 1.1v 249.755n 1.1v 254.745n 1.1v 254.755n 1.1v 259.745n 1.1v 259.755n 1.1v 264.745n 1.1v 264.755n 1.1v 269.745n 1.1v 269.755n 1.1v 274.745n 1.1v 274.755n 1.1v 279.745n 1.1v 279.755n 1.1v 284.745n 1.1v 284.755n 0.0v 289.745n 0.0v 289.755n 0.0v 294.745n 0.0v 294.755n 0.0v 299.745n 0.0v 299.755n 0.0v 304.745n 0.0v 304.755n 1.1v 309.745n 1.1v 309.755n 1.1v 314.745n 1.1v 314.755n 1.1v 319.745n 1.1v 319.755n 1.1v 324.745n 1.1v 324.755n 1.1v 329.745n 1.1v 329.755n 0.0v 334.745n 0.0v 334.755n 0.0v 339.745n 0.0v 339.755n 0.0v 344.745n 0.0v 344.755n 1.1v 349.745n 1.1v 349.755n 1.1v 354.745n 1.1v 354.755n 1.1v 359.745n 1.1v 359.755n 1.1v 364.745n 1.1v 364.755n 1.1v 369.745n 1.1v 369.755n 0.0v 374.745n 0.0v 374.755n 1.1v 379.745n 1.1v 379.755n 1.1v 384.745n 1.1v 384.755n 0.0v 389.745n 0.0v 389.755n 0.0v 394.745n 0.0v 394.755n 0.0v 399.745n 0.0v 399.755n 0.0v 404.745n 0.0v 404.755n 0.0v 409.745n 0.0v 409.755n 0.0v 414.745n 0.0v 414.755n 1.1v 419.745n 1.1v 419.755n 0.0v 424.745n 0.0v 424.755n 0.0v 429.745n 0.0v 429.755n 1.1v 434.745n 1.1v 434.755n 1.1v 439.745n 1.1v 439.755n 1.1v 444.745n 1.1v 444.755n 1.1v 449.745n 1.1v 449.755n 1.1v 454.745n 1.1v 454.755n 1.1v 459.745n 1.1v 459.755n 1.1v 464.745n 1.1v 464.755n 1.1v 469.745n 1.1v 469.755n 1.1v 474.745n 1.1v 474.755n 1.1v 479.745n 1.1v 479.755n 0.0v 484.745n 0.0v 484.755n 1.1v 489.745n 1.1v 489.755n 1.1v 494.745n 1.1v 494.755n 0.0v 499.745n 0.0v 499.755n 0.0v 504.745n 0.0v 504.755n 0.0v 509.745n 0.0v 509.755n 0.0v 514.745n 0.0v 514.755n 0.0v 519.745n 0.0v 519.755n 0.0v 524.745n 0.0v 524.755n 0.0v 529.745n 0.0v 529.755n 0.0v 534.745n 0.0v 534.755n 1.1v 539.745n 1.1v 539.755n 0.0v 544.745n 0.0v 544.755n 0.0v 549.745n 0.0v 549.755n 0.0v 554.745n 0.0v 554.755n 0.0v 559.745n 0.0v 559.755n 0.0v 564.745n 0.0v 564.755n 0.0v 569.745n 0.0v 569.755n 1.1v 574.745n 1.1v 574.755n 1.1v 579.745n 1.1v 579.755n 1.1v 584.745n 1.1v 584.755n 0.0v 589.745n 0.0v 589.755n 0.0v 594.745n 0.0v 594.755n 0.0v 599.745n 0.0v 599.755n 1.1v 604.745n 1.1v 604.755n 1.1v 609.745n 1.1v 609.755n 1.1v 614.745n 1.1v 614.755n 1.1v 619.745n 1.1v 619.755n 1.1v 624.745n 1.1v 624.755n 1.1v 629.745n 1.1v 629.755n 1.1v 634.745n 1.1v 634.755n 1.1v 639.745n 1.1v 639.755n 1.1v 644.745n 1.1v 644.755n 1.1v 649.745n 1.1v 649.755n 1.1v 654.745n 1.1v 654.755n 1.1v 659.745n 1.1v 659.755n 1.1v 664.745n 1.1v 664.755n 1.1v 669.745n 1.1v 669.755n 1.1v 674.745n 1.1v 674.755n 1.1v 679.745n 1.1v 679.755n 1.1v 684.745n 1.1v 684.755n 1.1v 689.745n 1.1v 689.755n 1.1v 694.745n 1.1v 694.755n 1.1v 699.745n 1.1v 699.755n 1.1v 704.745n 1.1v 704.755n 1.1v 709.745n 1.1v 709.755n 1.1v 714.745n 1.1v 714.755n 1.1v 719.745n 1.1v 719.755n 1.1v 724.745n 1.1v 724.755n 0.0v 729.745n 0.0v 729.755n 0.0v 734.745n 0.0v 734.755n 0.0v 739.745n 0.0v 739.755n 0.0v 744.745n 0.0v 744.755n 0.0v 749.745n 0.0v 749.755n 0.0v 754.745n 0.0v 754.755n 0.0v 759.745n 0.0v 759.755n 0.0v 764.745n 0.0v 764.755n 0.0v 769.745n 0.0v 769.755n 0.0v 774.745n 0.0v 774.755n 0.0v 779.745n 0.0v 779.755n 0.0v 784.745n 0.0v 784.755n 0.0v 789.745n 0.0v 789.755n 0.0v 794.745n 0.0v 794.755n 1.1v 799.745n 1.1v 799.755n 1.1v 804.745n 1.1v 804.755n 1.1v 809.745n 1.1v 809.755n 1.1v 814.745n 1.1v 814.755n 1.1v 819.745n 1.1v 819.755n 1.1v 824.745n 1.1v 824.755n 1.1v 829.745n 1.1v 829.755n 1.1v 834.745n 1.1v 834.755n 1.1v 839.745n 1.1v 839.755n 0.0v 844.745n 0.0v 844.755n 0.0v 849.745n 0.0v 849.755n 0.0v 854.745n 0.0v 854.755n 0.0v 859.745n 0.0v 859.755n 0.0v 864.745n 0.0v 864.755n 0.0v 869.745n 0.0v 869.755n 1.1v 874.745n 1.1v 874.755n 1.1v 879.745n 1.1v 879.755n 1.1v 884.745n 1.1v 884.755n 1.1v 889.745n 1.1v 889.755n 1.1v 894.745n 1.1v 894.755n 0.0v 899.745n 0.0v 899.755n 0.0v 904.745n 0.0v 904.755n 0.0v 909.745n 0.0v 909.755n 0.0v 914.745n 0.0v 914.755n 0.0v 919.745n 0.0v 919.755n 0.0v 924.745n 0.0v 924.755n 0.0v 929.745n 0.0v 929.755n 0.0v 934.745n 0.0v 934.755n 0.0v 939.745n 0.0v 939.755n 1.1v 944.745n 1.1v 944.755n 1.1v 949.745n 1.1v 949.755n 1.1v 954.745n 1.1v 954.755n 1.1v 959.745n 1.1v 959.755n 1.1v 964.745n 1.1v 964.755n 1.1v 969.745n 1.1v 969.755n 1.1v 974.745n 1.1v 974.755n 1.1v 979.745n 1.1v 979.755n 1.1v 984.745n 1.1v 984.755n 0.0v 989.745n 0.0v 989.755n 0.0v 994.745n 0.0v 994.755n 0.0v 999.745n 0.0v 999.755n 0.0v 1004.745n 0.0v 1004.755n 0.0v 1009.745n 0.0v 1009.755n 0.0v 1014.745n 0.0v 1014.755n 0.0v 1019.745n 0.0v 1019.755n 0.0v 1024.745n 0.0v 1024.755n 0.0v )
* (time, data): [(0, 0), (5, 1), (10, 0), (15, 1), (20, 1), (25, 1), (30, 0), (35, 0), (40, 0), (45, 0), (50, 0), (55, 0), (60, 1), (65, 1), (70, 1), (75, 1), (80, 1), (85, 1), (90, 1), (95, 1), (100, 1), (105, 1), (110, 1), (115, 0), (120, 0), (125, 1), (130, 1), (135, 1), (140, 1), (145, 1), (150, 1), (155, 1), (160, 1), (165, 0), (170, 0), (175, 0), (180, 0), (185, 0), (190, 0), (195, 0), (200, 0), (205, 0), (210, 0), (215, 0), (220, 1), (225, 1), (230, 0), (235, 0), (240, 0), (245, 0), (250, 0), (255, 0), (260, 0), (265, 0), (270, 0), (275, 0), (280, 0), (285, 1), (290, 1), (295, 1), (300, 1), (305, 1), (310, 1), (315, 1), (320, 1), (325, 1), (330, 0), (335, 0), (340, 0), (345, 1), (350, 1), (355, 1), (360, 1), (365, 1), (370, 0), (375, 0), (380, 0), (385, 1), (390, 1), (395, 1), (400, 1), (405, 1), (410, 1), (415, 0), (420, 1), (425, 1), (430, 1), (435, 1), (440, 1), (445, 1), (450, 1), (455, 1), (460, 1), (465, 1), (470, 1), (475, 1), (480, 1), (485, 1), (490, 1), (495, 1), (500, 1), (505, 1), (510, 1), (515, 1), (520, 0), (525, 0), (530, 0), (535, 1), (540, 0), (545, 0), (550, 0), (555, 0), (560, 0), (565, 0), (570, 1), (575, 1), (580, 1), (585, 1), (590, 1), (595, 1), (600, 0), (605, 0), (610, 0), (615, 0), (620, 0), (625, 0), (630, 0), (635, 0), (640, 0), (645, 0), (650, 1), (655, 0), (660, 0), (665, 0), (670, 0), (675, 0), (680, 0), (685, 0), (690, 0), (695, 0), (700, 0), (705, 0), (710, 0), (715, 1), (720, 1), (725, 1), (730, 1), (735, 1), (740, 1), (745, 1), (750, 1), (755, 1), (760, 1), (765, 1), (770, 1), (775, 1), (780, 1), (785, 1), (790, 1), (795, 0), (800, 0), (805, 0), (810, 0), (815, 0), (820, 0), (825, 0), (830, 0), (835, 0), (840, 0), (845, 0), (850, 0), (855, 0), (860, 0), (865, 0), (870, 0), (875, 0), (880, 0), (885, 0), (890, 0), (895, 0), (900, 0), (905, 0), (910, 0), (915, 0), (920, 1), (925, 1), (930, 1), (935, 1), (940, 1), (945, 1), (950, 1), (955, 1), (960, 1), (965, 1), (970, 1), (975, 1), (980, 1), (985, 0), (990, 0), (995, 0), (1000, 0), (1005, 0), (1010, 0), (1015, 0), (1020, 1), (1025, 1)]
Vdin0_12  din0_12  0 PWL (0n 0.0v 4.745n 0.0v 4.755n 1.1v 9.745n 1.1v 9.755n 0.0v 14.745n 0.0v 14.755n 1.1v 19.745n 1.1v 19.755n 1.1v 24.745n 1.1v 24.755n 1.1v 29.745n 1.1v 29.755n 0.0v 34.745n 0.0v 34.755n 0.0v 39.745n 0.0v 39.755n 0.0v 44.745n 0.0v 44.755n 0.0v 49.745n 0.0v 49.755n 0.0v 54.745n 0.0v 54.755n 0.0v 59.745n 0.0v 59.755n 1.1v 64.745n 1.1v 64.755n 1.1v 69.745n 1.1v 69.755n 1.1v 74.745n 1.1v 74.755n 1.1v 79.745n 1.1v 79.755n 1.1v 84.745n 1.1v 84.755n 1.1v 89.745n 1.1v 89.755n 1.1v 94.745n 1.1v 94.755n 1.1v 99.745n 1.1v 99.755n 1.1v 104.745n 1.1v 104.755n 1.1v 109.745n 1.1v 109.755n 1.1v 114.745n 1.1v 114.755n 0.0v 119.745n 0.0v 119.755n 0.0v 124.745n 0.0v 124.755n 1.1v 129.745n 1.1v 129.755n 1.1v 134.745n 1.1v 134.755n 1.1v 139.745n 1.1v 139.755n 1.1v 144.745n 1.1v 144.755n 1.1v 149.745n 1.1v 149.755n 1.1v 154.745n 1.1v 154.755n 1.1v 159.745n 1.1v 159.755n 1.1v 164.745n 1.1v 164.755n 0.0v 169.745n 0.0v 169.755n 0.0v 174.745n 0.0v 174.755n 0.0v 179.745n 0.0v 179.755n 0.0v 184.745n 0.0v 184.755n 0.0v 189.745n 0.0v 189.755n 0.0v 194.745n 0.0v 194.755n 0.0v 199.745n 0.0v 199.755n 0.0v 204.745n 0.0v 204.755n 0.0v 209.745n 0.0v 209.755n 0.0v 214.745n 0.0v 214.755n 0.0v 219.745n 0.0v 219.755n 1.1v 224.745n 1.1v 224.755n 1.1v 229.745n 1.1v 229.755n 0.0v 234.745n 0.0v 234.755n 0.0v 239.745n 0.0v 239.755n 0.0v 244.745n 0.0v 244.755n 0.0v 249.745n 0.0v 249.755n 0.0v 254.745n 0.0v 254.755n 0.0v 259.745n 0.0v 259.755n 0.0v 264.745n 0.0v 264.755n 0.0v 269.745n 0.0v 269.755n 0.0v 274.745n 0.0v 274.755n 0.0v 279.745n 0.0v 279.755n 0.0v 284.745n 0.0v 284.755n 1.1v 289.745n 1.1v 289.755n 1.1v 294.745n 1.1v 294.755n 1.1v 299.745n 1.1v 299.755n 1.1v 304.745n 1.1v 304.755n 1.1v 309.745n 1.1v 309.755n 1.1v 314.745n 1.1v 314.755n 1.1v 319.745n 1.1v 319.755n 1.1v 324.745n 1.1v 324.755n 1.1v 329.745n 1.1v 329.755n 0.0v 334.745n 0.0v 334.755n 0.0v 339.745n 0.0v 339.755n 0.0v 344.745n 0.0v 344.755n 1.1v 349.745n 1.1v 349.755n 1.1v 354.745n 1.1v 354.755n 1.1v 359.745n 1.1v 359.755n 1.1v 364.745n 1.1v 364.755n 1.1v 369.745n 1.1v 369.755n 0.0v 374.745n 0.0v 374.755n 0.0v 379.745n 0.0v 379.755n 0.0v 384.745n 0.0v 384.755n 1.1v 389.745n 1.1v 389.755n 1.1v 394.745n 1.1v 394.755n 1.1v 399.745n 1.1v 399.755n 1.1v 404.745n 1.1v 404.755n 1.1v 409.745n 1.1v 409.755n 1.1v 414.745n 1.1v 414.755n 0.0v 419.745n 0.0v 419.755n 1.1v 424.745n 1.1v 424.755n 1.1v 429.745n 1.1v 429.755n 1.1v 434.745n 1.1v 434.755n 1.1v 439.745n 1.1v 439.755n 1.1v 444.745n 1.1v 444.755n 1.1v 449.745n 1.1v 449.755n 1.1v 454.745n 1.1v 454.755n 1.1v 459.745n 1.1v 459.755n 1.1v 464.745n 1.1v 464.755n 1.1v 469.745n 1.1v 469.755n 1.1v 474.745n 1.1v 474.755n 1.1v 479.745n 1.1v 479.755n 1.1v 484.745n 1.1v 484.755n 1.1v 489.745n 1.1v 489.755n 1.1v 494.745n 1.1v 494.755n 1.1v 499.745n 1.1v 499.755n 1.1v 504.745n 1.1v 504.755n 1.1v 509.745n 1.1v 509.755n 1.1v 514.745n 1.1v 514.755n 1.1v 519.745n 1.1v 519.755n 0.0v 524.745n 0.0v 524.755n 0.0v 529.745n 0.0v 529.755n 0.0v 534.745n 0.0v 534.755n 1.1v 539.745n 1.1v 539.755n 0.0v 544.745n 0.0v 544.755n 0.0v 549.745n 0.0v 549.755n 0.0v 554.745n 0.0v 554.755n 0.0v 559.745n 0.0v 559.755n 0.0v 564.745n 0.0v 564.755n 0.0v 569.745n 0.0v 569.755n 1.1v 574.745n 1.1v 574.755n 1.1v 579.745n 1.1v 579.755n 1.1v 584.745n 1.1v 584.755n 1.1v 589.745n 1.1v 589.755n 1.1v 594.745n 1.1v 594.755n 1.1v 599.745n 1.1v 599.755n 0.0v 604.745n 0.0v 604.755n 0.0v 609.745n 0.0v 609.755n 0.0v 614.745n 0.0v 614.755n 0.0v 619.745n 0.0v 619.755n 0.0v 624.745n 0.0v 624.755n 0.0v 629.745n 0.0v 629.755n 0.0v 634.745n 0.0v 634.755n 0.0v 639.745n 0.0v 639.755n 0.0v 644.745n 0.0v 644.755n 0.0v 649.745n 0.0v 649.755n 1.1v 654.745n 1.1v 654.755n 0.0v 659.745n 0.0v 659.755n 0.0v 664.745n 0.0v 664.755n 0.0v 669.745n 0.0v 669.755n 0.0v 674.745n 0.0v 674.755n 0.0v 679.745n 0.0v 679.755n 0.0v 684.745n 0.0v 684.755n 0.0v 689.745n 0.0v 689.755n 0.0v 694.745n 0.0v 694.755n 0.0v 699.745n 0.0v 699.755n 0.0v 704.745n 0.0v 704.755n 0.0v 709.745n 0.0v 709.755n 0.0v 714.745n 0.0v 714.755n 1.1v 719.745n 1.1v 719.755n 1.1v 724.745n 1.1v 724.755n 1.1v 729.745n 1.1v 729.755n 1.1v 734.745n 1.1v 734.755n 1.1v 739.745n 1.1v 739.755n 1.1v 744.745n 1.1v 744.755n 1.1v 749.745n 1.1v 749.755n 1.1v 754.745n 1.1v 754.755n 1.1v 759.745n 1.1v 759.755n 1.1v 764.745n 1.1v 764.755n 1.1v 769.745n 1.1v 769.755n 1.1v 774.745n 1.1v 774.755n 1.1v 779.745n 1.1v 779.755n 1.1v 784.745n 1.1v 784.755n 1.1v 789.745n 1.1v 789.755n 1.1v 794.745n 1.1v 794.755n 0.0v 799.745n 0.0v 799.755n 0.0v 804.745n 0.0v 804.755n 0.0v 809.745n 0.0v 809.755n 0.0v 814.745n 0.0v 814.755n 0.0v 819.745n 0.0v 819.755n 0.0v 824.745n 0.0v 824.755n 0.0v 829.745n 0.0v 829.755n 0.0v 834.745n 0.0v 834.755n 0.0v 839.745n 0.0v 839.755n 0.0v 844.745n 0.0v 844.755n 0.0v 849.745n 0.0v 849.755n 0.0v 854.745n 0.0v 854.755n 0.0v 859.745n 0.0v 859.755n 0.0v 864.745n 0.0v 864.755n 0.0v 869.745n 0.0v 869.755n 0.0v 874.745n 0.0v 874.755n 0.0v 879.745n 0.0v 879.755n 0.0v 884.745n 0.0v 884.755n 0.0v 889.745n 0.0v 889.755n 0.0v 894.745n 0.0v 894.755n 0.0v 899.745n 0.0v 899.755n 0.0v 904.745n 0.0v 904.755n 0.0v 909.745n 0.0v 909.755n 0.0v 914.745n 0.0v 914.755n 0.0v 919.745n 0.0v 919.755n 1.1v 924.745n 1.1v 924.755n 1.1v 929.745n 1.1v 929.755n 1.1v 934.745n 1.1v 934.755n 1.1v 939.745n 1.1v 939.755n 1.1v 944.745n 1.1v 944.755n 1.1v 949.745n 1.1v 949.755n 1.1v 954.745n 1.1v 954.755n 1.1v 959.745n 1.1v 959.755n 1.1v 964.745n 1.1v 964.755n 1.1v 969.745n 1.1v 969.755n 1.1v 974.745n 1.1v 974.755n 1.1v 979.745n 1.1v 979.755n 1.1v 984.745n 1.1v 984.755n 0.0v 989.745n 0.0v 989.755n 0.0v 994.745n 0.0v 994.755n 0.0v 999.745n 0.0v 999.755n 0.0v 1004.745n 0.0v 1004.755n 0.0v 1009.745n 0.0v 1009.755n 0.0v 1014.745n 0.0v 1014.755n 0.0v 1019.745n 0.0v 1019.755n 1.1v 1024.745n 1.1v 1024.755n 1.1v )
* (time, data): [(0, 0), (5, 1), (10, 0), (15, 0), (20, 0), (25, 0), (30, 0), (35, 0), (40, 0), (45, 0), (50, 0), (55, 0), (60, 0), (65, 0), (70, 1), (75, 1), (80, 1), (85, 1), (90, 1), (95, 1), (100, 1), (105, 1), (110, 1), (115, 0), (120, 0), (125, 1), (130, 1), (135, 0), (140, 0), (145, 0), (150, 0), (155, 0), (160, 0), (165, 1), (170, 1), (175, 1), (180, 1), (185, 1), (190, 1), (195, 1), (200, 0), (205, 0), (210, 0), (215, 0), (220, 0), (225, 0), (230, 0), (235, 0), (240, 0), (245, 0), (250, 0), (255, 0), (260, 0), (265, 0), (270, 0), (275, 0), (280, 0), (285, 0), (290, 0), (295, 0), (300, 0), (305, 0), (310, 0), (315, 0), (320, 0), (325, 0), (330, 1), (335, 1), (340, 1), (345, 0), (350, 0), (355, 0), (360, 0), (365, 0), (370, 1), (375, 0), (380, 0), (385, 1), (390, 1), (395, 1), (400, 1), (405, 1), (410, 1), (415, 0), (420, 0), (425, 0), (430, 1), (435, 1), (440, 1), (445, 1), (450, 1), (455, 1), (460, 1), (465, 1), (470, 1), (475, 1), (480, 1), (485, 1), (490, 1), (495, 0), (500, 0), (505, 0), (510, 0), (515, 0), (520, 0), (525, 0), (530, 0), (535, 1), (540, 1), (545, 1), (550, 1), (555, 0), (560, 0), (565, 0), (570, 0), (575, 0), (580, 0), (585, 1), (590, 1), (595, 1), (600, 0), (605, 0), (610, 0), (615, 0), (620, 0), (625, 0), (630, 0), (635, 0), (640, 0), (645, 0), (650, 0), (655, 1), (660, 1), (665, 1), (670, 1), (675, 1), (680, 1), (685, 1), (690, 0), (695, 0), (700, 0), (705, 0), (710, 0), (715, 0), (720, 0), (725, 1), (730, 1), (735, 1), (740, 1), (745, 1), (750, 1), (755, 1), (760, 1), (765, 1), (770, 1), (775, 1), (780, 1), (785, 1), (790, 1), (795, 1), (800, 1), (805, 1), (810, 1), (815, 1), (820, 1), (825, 1), (830, 1), (835, 1), (840, 0), (845, 0), (850, 0), (855, 0), (860, 0), (865, 0), (870, 0), (875, 0), (880, 0), (885, 0), (890, 0), (895, 1), (900, 1), (905, 1), (910, 1), (915, 1), (920, 1), (925, 1), (930, 1), (935, 1), (940, 0), (945, 0), (950, 0), (955, 0), (960, 0), (965, 0), (970, 0), (975, 0), (980, 0), (985, 0), (990, 1), (995, 1), (1000, 1), (1005, 1), (1010, 1), (1015, 1), (1020, 1), (1025, 1)]
Vdin0_13  din0_13  0 PWL (0n 0.0v 4.745n 0.0v 4.755n 1.1v 9.745n 1.1v 9.755n 0.0v 14.745n 0.0v 14.755n 0.0v 19.745n 0.0v 19.755n 0.0v 24.745n 0.0v 24.755n 0.0v 29.745n 0.0v 29.755n 0.0v 34.745n 0.0v 34.755n 0.0v 39.745n 0.0v 39.755n 0.0v 44.745n 0.0v 44.755n 0.0v 49.745n 0.0v 49.755n 0.0v 54.745n 0.0v 54.755n 0.0v 59.745n 0.0v 59.755n 0.0v 64.745n 0.0v 64.755n 0.0v 69.745n 0.0v 69.755n 1.1v 74.745n 1.1v 74.755n 1.1v 79.745n 1.1v 79.755n 1.1v 84.745n 1.1v 84.755n 1.1v 89.745n 1.1v 89.755n 1.1v 94.745n 1.1v 94.755n 1.1v 99.745n 1.1v 99.755n 1.1v 104.745n 1.1v 104.755n 1.1v 109.745n 1.1v 109.755n 1.1v 114.745n 1.1v 114.755n 0.0v 119.745n 0.0v 119.755n 0.0v 124.745n 0.0v 124.755n 1.1v 129.745n 1.1v 129.755n 1.1v 134.745n 1.1v 134.755n 0.0v 139.745n 0.0v 139.755n 0.0v 144.745n 0.0v 144.755n 0.0v 149.745n 0.0v 149.755n 0.0v 154.745n 0.0v 154.755n 0.0v 159.745n 0.0v 159.755n 0.0v 164.745n 0.0v 164.755n 1.1v 169.745n 1.1v 169.755n 1.1v 174.745n 1.1v 174.755n 1.1v 179.745n 1.1v 179.755n 1.1v 184.745n 1.1v 184.755n 1.1v 189.745n 1.1v 189.755n 1.1v 194.745n 1.1v 194.755n 1.1v 199.745n 1.1v 199.755n 0.0v 204.745n 0.0v 204.755n 0.0v 209.745n 0.0v 209.755n 0.0v 214.745n 0.0v 214.755n 0.0v 219.745n 0.0v 219.755n 0.0v 224.745n 0.0v 224.755n 0.0v 229.745n 0.0v 229.755n 0.0v 234.745n 0.0v 234.755n 0.0v 239.745n 0.0v 239.755n 0.0v 244.745n 0.0v 244.755n 0.0v 249.745n 0.0v 249.755n 0.0v 254.745n 0.0v 254.755n 0.0v 259.745n 0.0v 259.755n 0.0v 264.745n 0.0v 264.755n 0.0v 269.745n 0.0v 269.755n 0.0v 274.745n 0.0v 274.755n 0.0v 279.745n 0.0v 279.755n 0.0v 284.745n 0.0v 284.755n 0.0v 289.745n 0.0v 289.755n 0.0v 294.745n 0.0v 294.755n 0.0v 299.745n 0.0v 299.755n 0.0v 304.745n 0.0v 304.755n 0.0v 309.745n 0.0v 309.755n 0.0v 314.745n 0.0v 314.755n 0.0v 319.745n 0.0v 319.755n 0.0v 324.745n 0.0v 324.755n 0.0v 329.745n 0.0v 329.755n 1.1v 334.745n 1.1v 334.755n 1.1v 339.745n 1.1v 339.755n 1.1v 344.745n 1.1v 344.755n 0.0v 349.745n 0.0v 349.755n 0.0v 354.745n 0.0v 354.755n 0.0v 359.745n 0.0v 359.755n 0.0v 364.745n 0.0v 364.755n 0.0v 369.745n 0.0v 369.755n 1.1v 374.745n 1.1v 374.755n 0.0v 379.745n 0.0v 379.755n 0.0v 384.745n 0.0v 384.755n 1.1v 389.745n 1.1v 389.755n 1.1v 394.745n 1.1v 394.755n 1.1v 399.745n 1.1v 399.755n 1.1v 404.745n 1.1v 404.755n 1.1v 409.745n 1.1v 409.755n 1.1v 414.745n 1.1v 414.755n 0.0v 419.745n 0.0v 419.755n 0.0v 424.745n 0.0v 424.755n 0.0v 429.745n 0.0v 429.755n 1.1v 434.745n 1.1v 434.755n 1.1v 439.745n 1.1v 439.755n 1.1v 444.745n 1.1v 444.755n 1.1v 449.745n 1.1v 449.755n 1.1v 454.745n 1.1v 454.755n 1.1v 459.745n 1.1v 459.755n 1.1v 464.745n 1.1v 464.755n 1.1v 469.745n 1.1v 469.755n 1.1v 474.745n 1.1v 474.755n 1.1v 479.745n 1.1v 479.755n 1.1v 484.745n 1.1v 484.755n 1.1v 489.745n 1.1v 489.755n 1.1v 494.745n 1.1v 494.755n 0.0v 499.745n 0.0v 499.755n 0.0v 504.745n 0.0v 504.755n 0.0v 509.745n 0.0v 509.755n 0.0v 514.745n 0.0v 514.755n 0.0v 519.745n 0.0v 519.755n 0.0v 524.745n 0.0v 524.755n 0.0v 529.745n 0.0v 529.755n 0.0v 534.745n 0.0v 534.755n 1.1v 539.745n 1.1v 539.755n 1.1v 544.745n 1.1v 544.755n 1.1v 549.745n 1.1v 549.755n 1.1v 554.745n 1.1v 554.755n 0.0v 559.745n 0.0v 559.755n 0.0v 564.745n 0.0v 564.755n 0.0v 569.745n 0.0v 569.755n 0.0v 574.745n 0.0v 574.755n 0.0v 579.745n 0.0v 579.755n 0.0v 584.745n 0.0v 584.755n 1.1v 589.745n 1.1v 589.755n 1.1v 594.745n 1.1v 594.755n 1.1v 599.745n 1.1v 599.755n 0.0v 604.745n 0.0v 604.755n 0.0v 609.745n 0.0v 609.755n 0.0v 614.745n 0.0v 614.755n 0.0v 619.745n 0.0v 619.755n 0.0v 624.745n 0.0v 624.755n 0.0v 629.745n 0.0v 629.755n 0.0v 634.745n 0.0v 634.755n 0.0v 639.745n 0.0v 639.755n 0.0v 644.745n 0.0v 644.755n 0.0v 649.745n 0.0v 649.755n 0.0v 654.745n 0.0v 654.755n 1.1v 659.745n 1.1v 659.755n 1.1v 664.745n 1.1v 664.755n 1.1v 669.745n 1.1v 669.755n 1.1v 674.745n 1.1v 674.755n 1.1v 679.745n 1.1v 679.755n 1.1v 684.745n 1.1v 684.755n 1.1v 689.745n 1.1v 689.755n 0.0v 694.745n 0.0v 694.755n 0.0v 699.745n 0.0v 699.755n 0.0v 704.745n 0.0v 704.755n 0.0v 709.745n 0.0v 709.755n 0.0v 714.745n 0.0v 714.755n 0.0v 719.745n 0.0v 719.755n 0.0v 724.745n 0.0v 724.755n 1.1v 729.745n 1.1v 729.755n 1.1v 734.745n 1.1v 734.755n 1.1v 739.745n 1.1v 739.755n 1.1v 744.745n 1.1v 744.755n 1.1v 749.745n 1.1v 749.755n 1.1v 754.745n 1.1v 754.755n 1.1v 759.745n 1.1v 759.755n 1.1v 764.745n 1.1v 764.755n 1.1v 769.745n 1.1v 769.755n 1.1v 774.745n 1.1v 774.755n 1.1v 779.745n 1.1v 779.755n 1.1v 784.745n 1.1v 784.755n 1.1v 789.745n 1.1v 789.755n 1.1v 794.745n 1.1v 794.755n 1.1v 799.745n 1.1v 799.755n 1.1v 804.745n 1.1v 804.755n 1.1v 809.745n 1.1v 809.755n 1.1v 814.745n 1.1v 814.755n 1.1v 819.745n 1.1v 819.755n 1.1v 824.745n 1.1v 824.755n 1.1v 829.745n 1.1v 829.755n 1.1v 834.745n 1.1v 834.755n 1.1v 839.745n 1.1v 839.755n 0.0v 844.745n 0.0v 844.755n 0.0v 849.745n 0.0v 849.755n 0.0v 854.745n 0.0v 854.755n 0.0v 859.745n 0.0v 859.755n 0.0v 864.745n 0.0v 864.755n 0.0v 869.745n 0.0v 869.755n 0.0v 874.745n 0.0v 874.755n 0.0v 879.745n 0.0v 879.755n 0.0v 884.745n 0.0v 884.755n 0.0v 889.745n 0.0v 889.755n 0.0v 894.745n 0.0v 894.755n 1.1v 899.745n 1.1v 899.755n 1.1v 904.745n 1.1v 904.755n 1.1v 909.745n 1.1v 909.755n 1.1v 914.745n 1.1v 914.755n 1.1v 919.745n 1.1v 919.755n 1.1v 924.745n 1.1v 924.755n 1.1v 929.745n 1.1v 929.755n 1.1v 934.745n 1.1v 934.755n 1.1v 939.745n 1.1v 939.755n 0.0v 944.745n 0.0v 944.755n 0.0v 949.745n 0.0v 949.755n 0.0v 954.745n 0.0v 954.755n 0.0v 959.745n 0.0v 959.755n 0.0v 964.745n 0.0v 964.755n 0.0v 969.745n 0.0v 969.755n 0.0v 974.745n 0.0v 974.755n 0.0v 979.745n 0.0v 979.755n 0.0v 984.745n 0.0v 984.755n 0.0v 989.745n 0.0v 989.755n 1.1v 994.745n 1.1v 994.755n 1.1v 999.745n 1.1v 999.755n 1.1v 1004.745n 1.1v 1004.755n 1.1v 1009.745n 1.1v 1009.755n 1.1v 1014.745n 1.1v 1014.755n 1.1v 1019.745n 1.1v 1019.755n 1.1v 1024.745n 1.1v 1024.755n 1.1v )
* (time, data): [(0, 0), (5, 1), (10, 0), (15, 0), (20, 0), (25, 0), (30, 1), (35, 1), (40, 0), (45, 0), (50, 0), (55, 0), (60, 1), (65, 1), (70, 1), (75, 1), (80, 1), (85, 1), (90, 1), (95, 1), (100, 0), (105, 0), (110, 0), (115, 1), (120, 1), (125, 0), (130, 0), (135, 0), (140, 0), (145, 1), (150, 1), (155, 1), (160, 1), (165, 0), (170, 0), (175, 0), (180, 0), (185, 0), (190, 0), (195, 0), (200, 0), (205, 0), (210, 0), (215, 0), (220, 0), (225, 0), (230, 0), (235, 0), (240, 0), (245, 1), (250, 1), (255, 0), (260, 0), (265, 0), (270, 1), (275, 1), (280, 1), (285, 1), (290, 1), (295, 1), (300, 1), (305, 0), (310, 0), (315, 0), (320, 0), (325, 1), (330, 1), (335, 1), (340, 1), (345, 0), (350, 0), (355, 0), (360, 0), (365, 0), (370, 1), (375, 1), (380, 1), (385, 1), (390, 1), (395, 1), (400, 1), (405, 1), (410, 1), (415, 1), (420, 1), (425, 1), (430, 0), (435, 0), (440, 0), (445, 0), (450, 0), (455, 0), (460, 0), (465, 0), (470, 0), (475, 0), (480, 1), (485, 0), (490, 0), (495, 0), (500, 0), (505, 0), (510, 0), (515, 0), (520, 0), (525, 0), (530, 0), (535, 1), (540, 1), (545, 1), (550, 1), (555, 0), (560, 0), (565, 0), (570, 0), (575, 0), (580, 0), (585, 1), (590, 1), (595, 1), (600, 0), (605, 0), (610, 0), (615, 0), (620, 0), (625, 0), (630, 0), (635, 0), (640, 0), (645, 0), (650, 0), (655, 1), (660, 1), (665, 1), (670, 1), (675, 1), (680, 1), (685, 1), (690, 1), (695, 1), (700, 1), (705, 1), (710, 1), (715, 1), (720, 1), (725, 0), (730, 0), (735, 0), (740, 0), (745, 0), (750, 0), (755, 0), (760, 0), (765, 0), (770, 0), (775, 0), (780, 0), (785, 0), (790, 0), (795, 1), (800, 1), (805, 1), (810, 1), (815, 1), (820, 1), (825, 1), (830, 1), (835, 1), (840, 1), (845, 1), (850, 1), (855, 1), (860, 1), (865, 1), (870, 0), (875, 0), (880, 0), (885, 0), (890, 0), (895, 0), (900, 0), (905, 0), (910, 0), (915, 0), (920, 1), (925, 1), (930, 1), (935, 1), (940, 0), (945, 0), (950, 0), (955, 0), (960, 0), (965, 0), (970, 0), (975, 0), (980, 0), (985, 0), (990, 0), (995, 0), (1000, 0), (1005, 0), (1010, 0), (1015, 1), (1020, 1), (1025, 1)]
Vdin0_14  din0_14  0 PWL (0n 0.0v 4.745n 0.0v 4.755n 1.1v 9.745n 1.1v 9.755n 0.0v 14.745n 0.0v 14.755n 0.0v 19.745n 0.0v 19.755n 0.0v 24.745n 0.0v 24.755n 0.0v 29.745n 0.0v 29.755n 1.1v 34.745n 1.1v 34.755n 1.1v 39.745n 1.1v 39.755n 0.0v 44.745n 0.0v 44.755n 0.0v 49.745n 0.0v 49.755n 0.0v 54.745n 0.0v 54.755n 0.0v 59.745n 0.0v 59.755n 1.1v 64.745n 1.1v 64.755n 1.1v 69.745n 1.1v 69.755n 1.1v 74.745n 1.1v 74.755n 1.1v 79.745n 1.1v 79.755n 1.1v 84.745n 1.1v 84.755n 1.1v 89.745n 1.1v 89.755n 1.1v 94.745n 1.1v 94.755n 1.1v 99.745n 1.1v 99.755n 0.0v 104.745n 0.0v 104.755n 0.0v 109.745n 0.0v 109.755n 0.0v 114.745n 0.0v 114.755n 1.1v 119.745n 1.1v 119.755n 1.1v 124.745n 1.1v 124.755n 0.0v 129.745n 0.0v 129.755n 0.0v 134.745n 0.0v 134.755n 0.0v 139.745n 0.0v 139.755n 0.0v 144.745n 0.0v 144.755n 1.1v 149.745n 1.1v 149.755n 1.1v 154.745n 1.1v 154.755n 1.1v 159.745n 1.1v 159.755n 1.1v 164.745n 1.1v 164.755n 0.0v 169.745n 0.0v 169.755n 0.0v 174.745n 0.0v 174.755n 0.0v 179.745n 0.0v 179.755n 0.0v 184.745n 0.0v 184.755n 0.0v 189.745n 0.0v 189.755n 0.0v 194.745n 0.0v 194.755n 0.0v 199.745n 0.0v 199.755n 0.0v 204.745n 0.0v 204.755n 0.0v 209.745n 0.0v 209.755n 0.0v 214.745n 0.0v 214.755n 0.0v 219.745n 0.0v 219.755n 0.0v 224.745n 0.0v 224.755n 0.0v 229.745n 0.0v 229.755n 0.0v 234.745n 0.0v 234.755n 0.0v 239.745n 0.0v 239.755n 0.0v 244.745n 0.0v 244.755n 1.1v 249.745n 1.1v 249.755n 1.1v 254.745n 1.1v 254.755n 0.0v 259.745n 0.0v 259.755n 0.0v 264.745n 0.0v 264.755n 0.0v 269.745n 0.0v 269.755n 1.1v 274.745n 1.1v 274.755n 1.1v 279.745n 1.1v 279.755n 1.1v 284.745n 1.1v 284.755n 1.1v 289.745n 1.1v 289.755n 1.1v 294.745n 1.1v 294.755n 1.1v 299.745n 1.1v 299.755n 1.1v 304.745n 1.1v 304.755n 0.0v 309.745n 0.0v 309.755n 0.0v 314.745n 0.0v 314.755n 0.0v 319.745n 0.0v 319.755n 0.0v 324.745n 0.0v 324.755n 1.1v 329.745n 1.1v 329.755n 1.1v 334.745n 1.1v 334.755n 1.1v 339.745n 1.1v 339.755n 1.1v 344.745n 1.1v 344.755n 0.0v 349.745n 0.0v 349.755n 0.0v 354.745n 0.0v 354.755n 0.0v 359.745n 0.0v 359.755n 0.0v 364.745n 0.0v 364.755n 0.0v 369.745n 0.0v 369.755n 1.1v 374.745n 1.1v 374.755n 1.1v 379.745n 1.1v 379.755n 1.1v 384.745n 1.1v 384.755n 1.1v 389.745n 1.1v 389.755n 1.1v 394.745n 1.1v 394.755n 1.1v 399.745n 1.1v 399.755n 1.1v 404.745n 1.1v 404.755n 1.1v 409.745n 1.1v 409.755n 1.1v 414.745n 1.1v 414.755n 1.1v 419.745n 1.1v 419.755n 1.1v 424.745n 1.1v 424.755n 1.1v 429.745n 1.1v 429.755n 0.0v 434.745n 0.0v 434.755n 0.0v 439.745n 0.0v 439.755n 0.0v 444.745n 0.0v 444.755n 0.0v 449.745n 0.0v 449.755n 0.0v 454.745n 0.0v 454.755n 0.0v 459.745n 0.0v 459.755n 0.0v 464.745n 0.0v 464.755n 0.0v 469.745n 0.0v 469.755n 0.0v 474.745n 0.0v 474.755n 0.0v 479.745n 0.0v 479.755n 1.1v 484.745n 1.1v 484.755n 0.0v 489.745n 0.0v 489.755n 0.0v 494.745n 0.0v 494.755n 0.0v 499.745n 0.0v 499.755n 0.0v 504.745n 0.0v 504.755n 0.0v 509.745n 0.0v 509.755n 0.0v 514.745n 0.0v 514.755n 0.0v 519.745n 0.0v 519.755n 0.0v 524.745n 0.0v 524.755n 0.0v 529.745n 0.0v 529.755n 0.0v 534.745n 0.0v 534.755n 1.1v 539.745n 1.1v 539.755n 1.1v 544.745n 1.1v 544.755n 1.1v 549.745n 1.1v 549.755n 1.1v 554.745n 1.1v 554.755n 0.0v 559.745n 0.0v 559.755n 0.0v 564.745n 0.0v 564.755n 0.0v 569.745n 0.0v 569.755n 0.0v 574.745n 0.0v 574.755n 0.0v 579.745n 0.0v 579.755n 0.0v 584.745n 0.0v 584.755n 1.1v 589.745n 1.1v 589.755n 1.1v 594.745n 1.1v 594.755n 1.1v 599.745n 1.1v 599.755n 0.0v 604.745n 0.0v 604.755n 0.0v 609.745n 0.0v 609.755n 0.0v 614.745n 0.0v 614.755n 0.0v 619.745n 0.0v 619.755n 0.0v 624.745n 0.0v 624.755n 0.0v 629.745n 0.0v 629.755n 0.0v 634.745n 0.0v 634.755n 0.0v 639.745n 0.0v 639.755n 0.0v 644.745n 0.0v 644.755n 0.0v 649.745n 0.0v 649.755n 0.0v 654.745n 0.0v 654.755n 1.1v 659.745n 1.1v 659.755n 1.1v 664.745n 1.1v 664.755n 1.1v 669.745n 1.1v 669.755n 1.1v 674.745n 1.1v 674.755n 1.1v 679.745n 1.1v 679.755n 1.1v 684.745n 1.1v 684.755n 1.1v 689.745n 1.1v 689.755n 1.1v 694.745n 1.1v 694.755n 1.1v 699.745n 1.1v 699.755n 1.1v 704.745n 1.1v 704.755n 1.1v 709.745n 1.1v 709.755n 1.1v 714.745n 1.1v 714.755n 1.1v 719.745n 1.1v 719.755n 1.1v 724.745n 1.1v 724.755n 0.0v 729.745n 0.0v 729.755n 0.0v 734.745n 0.0v 734.755n 0.0v 739.745n 0.0v 739.755n 0.0v 744.745n 0.0v 744.755n 0.0v 749.745n 0.0v 749.755n 0.0v 754.745n 0.0v 754.755n 0.0v 759.745n 0.0v 759.755n 0.0v 764.745n 0.0v 764.755n 0.0v 769.745n 0.0v 769.755n 0.0v 774.745n 0.0v 774.755n 0.0v 779.745n 0.0v 779.755n 0.0v 784.745n 0.0v 784.755n 0.0v 789.745n 0.0v 789.755n 0.0v 794.745n 0.0v 794.755n 1.1v 799.745n 1.1v 799.755n 1.1v 804.745n 1.1v 804.755n 1.1v 809.745n 1.1v 809.755n 1.1v 814.745n 1.1v 814.755n 1.1v 819.745n 1.1v 819.755n 1.1v 824.745n 1.1v 824.755n 1.1v 829.745n 1.1v 829.755n 1.1v 834.745n 1.1v 834.755n 1.1v 839.745n 1.1v 839.755n 1.1v 844.745n 1.1v 844.755n 1.1v 849.745n 1.1v 849.755n 1.1v 854.745n 1.1v 854.755n 1.1v 859.745n 1.1v 859.755n 1.1v 864.745n 1.1v 864.755n 1.1v 869.745n 1.1v 869.755n 0.0v 874.745n 0.0v 874.755n 0.0v 879.745n 0.0v 879.755n 0.0v 884.745n 0.0v 884.755n 0.0v 889.745n 0.0v 889.755n 0.0v 894.745n 0.0v 894.755n 0.0v 899.745n 0.0v 899.755n 0.0v 904.745n 0.0v 904.755n 0.0v 909.745n 0.0v 909.755n 0.0v 914.745n 0.0v 914.755n 0.0v 919.745n 0.0v 919.755n 1.1v 924.745n 1.1v 924.755n 1.1v 929.745n 1.1v 929.755n 1.1v 934.745n 1.1v 934.755n 1.1v 939.745n 1.1v 939.755n 0.0v 944.745n 0.0v 944.755n 0.0v 949.745n 0.0v 949.755n 0.0v 954.745n 0.0v 954.755n 0.0v 959.745n 0.0v 959.755n 0.0v 964.745n 0.0v 964.755n 0.0v 969.745n 0.0v 969.755n 0.0v 974.745n 0.0v 974.755n 0.0v 979.745n 0.0v 979.755n 0.0v 984.745n 0.0v 984.755n 0.0v 989.745n 0.0v 989.755n 0.0v 994.745n 0.0v 994.755n 0.0v 999.745n 0.0v 999.755n 0.0v 1004.745n 0.0v 1004.755n 0.0v 1009.745n 0.0v 1009.755n 0.0v 1014.745n 0.0v 1014.755n 1.1v 1019.745n 1.1v 1019.755n 1.1v 1024.745n 1.1v 1024.755n 1.1v )
* (time, data): [(0, 0), (5, 0), (10, 0), (15, 1), (20, 1), (25, 1), (30, 1), (35, 1), (40, 1), (45, 1), (50, 1), (55, 1), (60, 1), (65, 1), (70, 1), (75, 1), (80, 1), (85, 1), (90, 1), (95, 1), (100, 0), (105, 0), (110, 0), (115, 1), (120, 1), (125, 0), (130, 0), (135, 0), (140, 1), (145, 0), (150, 0), (155, 0), (160, 0), (165, 0), (170, 0), (175, 0), (180, 0), (185, 0), (190, 0), (195, 0), (200, 0), (205, 0), (210, 0), (215, 0), (220, 1), (225, 1), (230, 0), (235, 0), (240, 0), (245, 0), (250, 0), (255, 0), (260, 0), (265, 0), (270, 0), (275, 0), (280, 0), (285, 0), (290, 0), (295, 0), (300, 0), (305, 1), (310, 1), (315, 1), (320, 1), (325, 0), (330, 0), (335, 0), (340, 0), (345, 1), (350, 1), (355, 1), (360, 1), (365, 1), (370, 1), (375, 1), (380, 1), (385, 0), (390, 0), (395, 0), (400, 0), (405, 0), (410, 0), (415, 1), (420, 1), (425, 1), (430, 1), (435, 1), (440, 1), (445, 1), (450, 1), (455, 1), (460, 1), (465, 1), (470, 1), (475, 1), (480, 1), (485, 0), (490, 0), (495, 0), (500, 0), (505, 0), (510, 0), (515, 0), (520, 0), (525, 0), (530, 0), (535, 0), (540, 0), (545, 0), (550, 0), (555, 0), (560, 0), (565, 0), (570, 1), (575, 1), (580, 1), (585, 1), (590, 1), (595, 1), (600, 1), (605, 1), (610, 1), (615, 1), (620, 0), (625, 0), (630, 0), (635, 0), (640, 0), (645, 0), (650, 1), (655, 0), (660, 0), (665, 0), (670, 0), (675, 0), (680, 0), (685, 0), (690, 0), (695, 0), (700, 0), (705, 0), (710, 0), (715, 1), (720, 1), (725, 0), (730, 0), (735, 0), (740, 0), (745, 0), (750, 0), (755, 0), (760, 0), (765, 0), (770, 0), (775, 0), (780, 0), (785, 0), (790, 0), (795, 1), (800, 1), (805, 1), (810, 1), (815, 1), (820, 1), (825, 1), (830, 1), (835, 1), (840, 0), (845, 0), (850, 0), (855, 0), (860, 0), (865, 0), (870, 1), (875, 1), (880, 1), (885, 1), (890, 1), (895, 0), (900, 0), (905, 0), (910, 0), (915, 0), (920, 0), (925, 0), (930, 0), (935, 0), (940, 1), (945, 1), (950, 1), (955, 1), (960, 1), (965, 1), (970, 1), (975, 1), (980, 1), (985, 1), (990, 1), (995, 1), (1000, 1), (1005, 1), (1010, 1), (1015, 0), (1020, 0), (1025, 0)]
Vdin0_15  din0_15  0 PWL (0n 0.0v 4.745n 0.0v 4.755n 0.0v 9.745n 0.0v 9.755n 0.0v 14.745n 0.0v 14.755n 1.1v 19.745n 1.1v 19.755n 1.1v 24.745n 1.1v 24.755n 1.1v 29.745n 1.1v 29.755n 1.1v 34.745n 1.1v 34.755n 1.1v 39.745n 1.1v 39.755n 1.1v 44.745n 1.1v 44.755n 1.1v 49.745n 1.1v 49.755n 1.1v 54.745n 1.1v 54.755n 1.1v 59.745n 1.1v 59.755n 1.1v 64.745n 1.1v 64.755n 1.1v 69.745n 1.1v 69.755n 1.1v 74.745n 1.1v 74.755n 1.1v 79.745n 1.1v 79.755n 1.1v 84.745n 1.1v 84.755n 1.1v 89.745n 1.1v 89.755n 1.1v 94.745n 1.1v 94.755n 1.1v 99.745n 1.1v 99.755n 0.0v 104.745n 0.0v 104.755n 0.0v 109.745n 0.0v 109.755n 0.0v 114.745n 0.0v 114.755n 1.1v 119.745n 1.1v 119.755n 1.1v 124.745n 1.1v 124.755n 0.0v 129.745n 0.0v 129.755n 0.0v 134.745n 0.0v 134.755n 0.0v 139.745n 0.0v 139.755n 1.1v 144.745n 1.1v 144.755n 0.0v 149.745n 0.0v 149.755n 0.0v 154.745n 0.0v 154.755n 0.0v 159.745n 0.0v 159.755n 0.0v 164.745n 0.0v 164.755n 0.0v 169.745n 0.0v 169.755n 0.0v 174.745n 0.0v 174.755n 0.0v 179.745n 0.0v 179.755n 0.0v 184.745n 0.0v 184.755n 0.0v 189.745n 0.0v 189.755n 0.0v 194.745n 0.0v 194.755n 0.0v 199.745n 0.0v 199.755n 0.0v 204.745n 0.0v 204.755n 0.0v 209.745n 0.0v 209.755n 0.0v 214.745n 0.0v 214.755n 0.0v 219.745n 0.0v 219.755n 1.1v 224.745n 1.1v 224.755n 1.1v 229.745n 1.1v 229.755n 0.0v 234.745n 0.0v 234.755n 0.0v 239.745n 0.0v 239.755n 0.0v 244.745n 0.0v 244.755n 0.0v 249.745n 0.0v 249.755n 0.0v 254.745n 0.0v 254.755n 0.0v 259.745n 0.0v 259.755n 0.0v 264.745n 0.0v 264.755n 0.0v 269.745n 0.0v 269.755n 0.0v 274.745n 0.0v 274.755n 0.0v 279.745n 0.0v 279.755n 0.0v 284.745n 0.0v 284.755n 0.0v 289.745n 0.0v 289.755n 0.0v 294.745n 0.0v 294.755n 0.0v 299.745n 0.0v 299.755n 0.0v 304.745n 0.0v 304.755n 1.1v 309.745n 1.1v 309.755n 1.1v 314.745n 1.1v 314.755n 1.1v 319.745n 1.1v 319.755n 1.1v 324.745n 1.1v 324.755n 0.0v 329.745n 0.0v 329.755n 0.0v 334.745n 0.0v 334.755n 0.0v 339.745n 0.0v 339.755n 0.0v 344.745n 0.0v 344.755n 1.1v 349.745n 1.1v 349.755n 1.1v 354.745n 1.1v 354.755n 1.1v 359.745n 1.1v 359.755n 1.1v 364.745n 1.1v 364.755n 1.1v 369.745n 1.1v 369.755n 1.1v 374.745n 1.1v 374.755n 1.1v 379.745n 1.1v 379.755n 1.1v 384.745n 1.1v 384.755n 0.0v 389.745n 0.0v 389.755n 0.0v 394.745n 0.0v 394.755n 0.0v 399.745n 0.0v 399.755n 0.0v 404.745n 0.0v 404.755n 0.0v 409.745n 0.0v 409.755n 0.0v 414.745n 0.0v 414.755n 1.1v 419.745n 1.1v 419.755n 1.1v 424.745n 1.1v 424.755n 1.1v 429.745n 1.1v 429.755n 1.1v 434.745n 1.1v 434.755n 1.1v 439.745n 1.1v 439.755n 1.1v 444.745n 1.1v 444.755n 1.1v 449.745n 1.1v 449.755n 1.1v 454.745n 1.1v 454.755n 1.1v 459.745n 1.1v 459.755n 1.1v 464.745n 1.1v 464.755n 1.1v 469.745n 1.1v 469.755n 1.1v 474.745n 1.1v 474.755n 1.1v 479.745n 1.1v 479.755n 1.1v 484.745n 1.1v 484.755n 0.0v 489.745n 0.0v 489.755n 0.0v 494.745n 0.0v 494.755n 0.0v 499.745n 0.0v 499.755n 0.0v 504.745n 0.0v 504.755n 0.0v 509.745n 0.0v 509.755n 0.0v 514.745n 0.0v 514.755n 0.0v 519.745n 0.0v 519.755n 0.0v 524.745n 0.0v 524.755n 0.0v 529.745n 0.0v 529.755n 0.0v 534.745n 0.0v 534.755n 0.0v 539.745n 0.0v 539.755n 0.0v 544.745n 0.0v 544.755n 0.0v 549.745n 0.0v 549.755n 0.0v 554.745n 0.0v 554.755n 0.0v 559.745n 0.0v 559.755n 0.0v 564.745n 0.0v 564.755n 0.0v 569.745n 0.0v 569.755n 1.1v 574.745n 1.1v 574.755n 1.1v 579.745n 1.1v 579.755n 1.1v 584.745n 1.1v 584.755n 1.1v 589.745n 1.1v 589.755n 1.1v 594.745n 1.1v 594.755n 1.1v 599.745n 1.1v 599.755n 1.1v 604.745n 1.1v 604.755n 1.1v 609.745n 1.1v 609.755n 1.1v 614.745n 1.1v 614.755n 1.1v 619.745n 1.1v 619.755n 0.0v 624.745n 0.0v 624.755n 0.0v 629.745n 0.0v 629.755n 0.0v 634.745n 0.0v 634.755n 0.0v 639.745n 0.0v 639.755n 0.0v 644.745n 0.0v 644.755n 0.0v 649.745n 0.0v 649.755n 1.1v 654.745n 1.1v 654.755n 0.0v 659.745n 0.0v 659.755n 0.0v 664.745n 0.0v 664.755n 0.0v 669.745n 0.0v 669.755n 0.0v 674.745n 0.0v 674.755n 0.0v 679.745n 0.0v 679.755n 0.0v 684.745n 0.0v 684.755n 0.0v 689.745n 0.0v 689.755n 0.0v 694.745n 0.0v 694.755n 0.0v 699.745n 0.0v 699.755n 0.0v 704.745n 0.0v 704.755n 0.0v 709.745n 0.0v 709.755n 0.0v 714.745n 0.0v 714.755n 1.1v 719.745n 1.1v 719.755n 1.1v 724.745n 1.1v 724.755n 0.0v 729.745n 0.0v 729.755n 0.0v 734.745n 0.0v 734.755n 0.0v 739.745n 0.0v 739.755n 0.0v 744.745n 0.0v 744.755n 0.0v 749.745n 0.0v 749.755n 0.0v 754.745n 0.0v 754.755n 0.0v 759.745n 0.0v 759.755n 0.0v 764.745n 0.0v 764.755n 0.0v 769.745n 0.0v 769.755n 0.0v 774.745n 0.0v 774.755n 0.0v 779.745n 0.0v 779.755n 0.0v 784.745n 0.0v 784.755n 0.0v 789.745n 0.0v 789.755n 0.0v 794.745n 0.0v 794.755n 1.1v 799.745n 1.1v 799.755n 1.1v 804.745n 1.1v 804.755n 1.1v 809.745n 1.1v 809.755n 1.1v 814.745n 1.1v 814.755n 1.1v 819.745n 1.1v 819.755n 1.1v 824.745n 1.1v 824.755n 1.1v 829.745n 1.1v 829.755n 1.1v 834.745n 1.1v 834.755n 1.1v 839.745n 1.1v 839.755n 0.0v 844.745n 0.0v 844.755n 0.0v 849.745n 0.0v 849.755n 0.0v 854.745n 0.0v 854.755n 0.0v 859.745n 0.0v 859.755n 0.0v 864.745n 0.0v 864.755n 0.0v 869.745n 0.0v 869.755n 1.1v 874.745n 1.1v 874.755n 1.1v 879.745n 1.1v 879.755n 1.1v 884.745n 1.1v 884.755n 1.1v 889.745n 1.1v 889.755n 1.1v 894.745n 1.1v 894.755n 0.0v 899.745n 0.0v 899.755n 0.0v 904.745n 0.0v 904.755n 0.0v 909.745n 0.0v 909.755n 0.0v 914.745n 0.0v 914.755n 0.0v 919.745n 0.0v 919.755n 0.0v 924.745n 0.0v 924.755n 0.0v 929.745n 0.0v 929.755n 0.0v 934.745n 0.0v 934.755n 0.0v 939.745n 0.0v 939.755n 1.1v 944.745n 1.1v 944.755n 1.1v 949.745n 1.1v 949.755n 1.1v 954.745n 1.1v 954.755n 1.1v 959.745n 1.1v 959.755n 1.1v 964.745n 1.1v 964.755n 1.1v 969.745n 1.1v 969.755n 1.1v 974.745n 1.1v 974.755n 1.1v 979.745n 1.1v 979.755n 1.1v 984.745n 1.1v 984.755n 1.1v 989.745n 1.1v 989.755n 1.1v 994.745n 1.1v 994.755n 1.1v 999.745n 1.1v 999.755n 1.1v 1004.745n 1.1v 1004.755n 1.1v 1009.745n 1.1v 1009.755n 1.1v 1014.745n 1.1v 1014.755n 0.0v 1019.745n 0.0v 1019.755n 0.0v 1024.745n 0.0v 1024.755n 0.0v )
* (time, data): [(0, 0), (5, 1), (10, 1), (15, 1), (20, 1), (25, 1), (30, 0), (35, 0), (40, 1), (45, 1), (50, 1), (55, 1), (60, 0), (65, 0), (70, 0), (75, 0), (80, 0), (85, 0), (90, 0), (95, 0), (100, 0), (105, 0), (110, 0), (115, 0), (120, 0), (125, 1), (130, 1), (135, 1), (140, 1), (145, 0), (150, 0), (155, 0), (160, 0), (165, 0), (170, 0), (175, 0), (180, 0), (185, 0), (190, 0), (195, 0), (200, 0), (205, 0), (210, 0), (215, 0), (220, 1), (225, 1), (230, 1), (235, 1), (240, 1), (245, 0), (250, 0), (255, 1), (260, 1), (265, 1), (270, 0), (275, 0), (280, 0), (285, 0), (290, 0), (295, 0), (300, 0), (305, 1), (310, 1), (315, 1), (320, 1), (325, 1), (330, 1), (335, 1), (340, 1), (345, 0), (350, 0), (355, 0), (360, 0), (365, 0), (370, 0), (375, 0), (380, 0), (385, 0), (390, 0), (395, 0), (400, 0), (405, 0), (410, 0), (415, 0), (420, 1), (425, 1), (430, 1), (435, 1), (440, 1), (445, 1), (450, 1), (455, 1), (460, 1), (465, 1), (470, 1), (475, 1), (480, 0), (485, 0), (490, 0), (495, 0), (500, 0), (505, 0), (510, 0), (515, 0), (520, 0), (525, 0), (530, 0), (535, 1), (540, 0), (545, 0), (550, 0), (555, 0), (560, 0), (565, 0), (570, 1), (575, 1), (580, 1), (585, 0), (590, 0), (595, 0), (600, 0), (605, 0), (610, 0), (615, 0), (620, 1), (625, 1), (630, 1), (635, 1), (640, 1), (645, 1), (650, 0), (655, 0), (660, 0), (665, 0), (670, 0), (675, 0), (680, 0), (685, 0), (690, 1), (695, 1), (700, 1), (705, 1), (710, 1), (715, 1), (720, 1), (725, 0), (730, 0), (735, 0), (740, 0), (745, 0), (750, 0), (755, 0), (760, 0), (765, 0), (770, 0), (775, 0), (780, 0), (785, 0), (790, 0), (795, 0), (800, 0), (805, 0), (810, 0), (815, 0), (820, 0), (825, 0), (830, 0), (835, 0), (840, 0), (845, 0), (850, 0), (855, 0), (860, 0), (865, 0), (870, 0), (875, 0), (880, 0), (885, 0), (890, 0), (895, 0), (900, 0), (905, 0), (910, 0), (915, 0), (920, 1), (925, 1), (930, 1), (935, 1), (940, 1), (945, 1), (950, 1), (955, 1), (960, 1), (965, 1), (970, 1), (975, 1), (980, 1), (985, 0), (990, 0), (995, 0), (1000, 0), (1005, 0), (1010, 0), (1015, 0), (1020, 1), (1025, 1)]
Vdin0_16  din0_16  0 PWL (0n 0.0v 4.745n 0.0v 4.755n 1.1v 9.745n 1.1v 9.755n 1.1v 14.745n 1.1v 14.755n 1.1v 19.745n 1.1v 19.755n 1.1v 24.745n 1.1v 24.755n 1.1v 29.745n 1.1v 29.755n 0.0v 34.745n 0.0v 34.755n 0.0v 39.745n 0.0v 39.755n 1.1v 44.745n 1.1v 44.755n 1.1v 49.745n 1.1v 49.755n 1.1v 54.745n 1.1v 54.755n 1.1v 59.745n 1.1v 59.755n 0.0v 64.745n 0.0v 64.755n 0.0v 69.745n 0.0v 69.755n 0.0v 74.745n 0.0v 74.755n 0.0v 79.745n 0.0v 79.755n 0.0v 84.745n 0.0v 84.755n 0.0v 89.745n 0.0v 89.755n 0.0v 94.745n 0.0v 94.755n 0.0v 99.745n 0.0v 99.755n 0.0v 104.745n 0.0v 104.755n 0.0v 109.745n 0.0v 109.755n 0.0v 114.745n 0.0v 114.755n 0.0v 119.745n 0.0v 119.755n 0.0v 124.745n 0.0v 124.755n 1.1v 129.745n 1.1v 129.755n 1.1v 134.745n 1.1v 134.755n 1.1v 139.745n 1.1v 139.755n 1.1v 144.745n 1.1v 144.755n 0.0v 149.745n 0.0v 149.755n 0.0v 154.745n 0.0v 154.755n 0.0v 159.745n 0.0v 159.755n 0.0v 164.745n 0.0v 164.755n 0.0v 169.745n 0.0v 169.755n 0.0v 174.745n 0.0v 174.755n 0.0v 179.745n 0.0v 179.755n 0.0v 184.745n 0.0v 184.755n 0.0v 189.745n 0.0v 189.755n 0.0v 194.745n 0.0v 194.755n 0.0v 199.745n 0.0v 199.755n 0.0v 204.745n 0.0v 204.755n 0.0v 209.745n 0.0v 209.755n 0.0v 214.745n 0.0v 214.755n 0.0v 219.745n 0.0v 219.755n 1.1v 224.745n 1.1v 224.755n 1.1v 229.745n 1.1v 229.755n 1.1v 234.745n 1.1v 234.755n 1.1v 239.745n 1.1v 239.755n 1.1v 244.745n 1.1v 244.755n 0.0v 249.745n 0.0v 249.755n 0.0v 254.745n 0.0v 254.755n 1.1v 259.745n 1.1v 259.755n 1.1v 264.745n 1.1v 264.755n 1.1v 269.745n 1.1v 269.755n 0.0v 274.745n 0.0v 274.755n 0.0v 279.745n 0.0v 279.755n 0.0v 284.745n 0.0v 284.755n 0.0v 289.745n 0.0v 289.755n 0.0v 294.745n 0.0v 294.755n 0.0v 299.745n 0.0v 299.755n 0.0v 304.745n 0.0v 304.755n 1.1v 309.745n 1.1v 309.755n 1.1v 314.745n 1.1v 314.755n 1.1v 319.745n 1.1v 319.755n 1.1v 324.745n 1.1v 324.755n 1.1v 329.745n 1.1v 329.755n 1.1v 334.745n 1.1v 334.755n 1.1v 339.745n 1.1v 339.755n 1.1v 344.745n 1.1v 344.755n 0.0v 349.745n 0.0v 349.755n 0.0v 354.745n 0.0v 354.755n 0.0v 359.745n 0.0v 359.755n 0.0v 364.745n 0.0v 364.755n 0.0v 369.745n 0.0v 369.755n 0.0v 374.745n 0.0v 374.755n 0.0v 379.745n 0.0v 379.755n 0.0v 384.745n 0.0v 384.755n 0.0v 389.745n 0.0v 389.755n 0.0v 394.745n 0.0v 394.755n 0.0v 399.745n 0.0v 399.755n 0.0v 404.745n 0.0v 404.755n 0.0v 409.745n 0.0v 409.755n 0.0v 414.745n 0.0v 414.755n 0.0v 419.745n 0.0v 419.755n 1.1v 424.745n 1.1v 424.755n 1.1v 429.745n 1.1v 429.755n 1.1v 434.745n 1.1v 434.755n 1.1v 439.745n 1.1v 439.755n 1.1v 444.745n 1.1v 444.755n 1.1v 449.745n 1.1v 449.755n 1.1v 454.745n 1.1v 454.755n 1.1v 459.745n 1.1v 459.755n 1.1v 464.745n 1.1v 464.755n 1.1v 469.745n 1.1v 469.755n 1.1v 474.745n 1.1v 474.755n 1.1v 479.745n 1.1v 479.755n 0.0v 484.745n 0.0v 484.755n 0.0v 489.745n 0.0v 489.755n 0.0v 494.745n 0.0v 494.755n 0.0v 499.745n 0.0v 499.755n 0.0v 504.745n 0.0v 504.755n 0.0v 509.745n 0.0v 509.755n 0.0v 514.745n 0.0v 514.755n 0.0v 519.745n 0.0v 519.755n 0.0v 524.745n 0.0v 524.755n 0.0v 529.745n 0.0v 529.755n 0.0v 534.745n 0.0v 534.755n 1.1v 539.745n 1.1v 539.755n 0.0v 544.745n 0.0v 544.755n 0.0v 549.745n 0.0v 549.755n 0.0v 554.745n 0.0v 554.755n 0.0v 559.745n 0.0v 559.755n 0.0v 564.745n 0.0v 564.755n 0.0v 569.745n 0.0v 569.755n 1.1v 574.745n 1.1v 574.755n 1.1v 579.745n 1.1v 579.755n 1.1v 584.745n 1.1v 584.755n 0.0v 589.745n 0.0v 589.755n 0.0v 594.745n 0.0v 594.755n 0.0v 599.745n 0.0v 599.755n 0.0v 604.745n 0.0v 604.755n 0.0v 609.745n 0.0v 609.755n 0.0v 614.745n 0.0v 614.755n 0.0v 619.745n 0.0v 619.755n 1.1v 624.745n 1.1v 624.755n 1.1v 629.745n 1.1v 629.755n 1.1v 634.745n 1.1v 634.755n 1.1v 639.745n 1.1v 639.755n 1.1v 644.745n 1.1v 644.755n 1.1v 649.745n 1.1v 649.755n 0.0v 654.745n 0.0v 654.755n 0.0v 659.745n 0.0v 659.755n 0.0v 664.745n 0.0v 664.755n 0.0v 669.745n 0.0v 669.755n 0.0v 674.745n 0.0v 674.755n 0.0v 679.745n 0.0v 679.755n 0.0v 684.745n 0.0v 684.755n 0.0v 689.745n 0.0v 689.755n 1.1v 694.745n 1.1v 694.755n 1.1v 699.745n 1.1v 699.755n 1.1v 704.745n 1.1v 704.755n 1.1v 709.745n 1.1v 709.755n 1.1v 714.745n 1.1v 714.755n 1.1v 719.745n 1.1v 719.755n 1.1v 724.745n 1.1v 724.755n 0.0v 729.745n 0.0v 729.755n 0.0v 734.745n 0.0v 734.755n 0.0v 739.745n 0.0v 739.755n 0.0v 744.745n 0.0v 744.755n 0.0v 749.745n 0.0v 749.755n 0.0v 754.745n 0.0v 754.755n 0.0v 759.745n 0.0v 759.755n 0.0v 764.745n 0.0v 764.755n 0.0v 769.745n 0.0v 769.755n 0.0v 774.745n 0.0v 774.755n 0.0v 779.745n 0.0v 779.755n 0.0v 784.745n 0.0v 784.755n 0.0v 789.745n 0.0v 789.755n 0.0v 794.745n 0.0v 794.755n 0.0v 799.745n 0.0v 799.755n 0.0v 804.745n 0.0v 804.755n 0.0v 809.745n 0.0v 809.755n 0.0v 814.745n 0.0v 814.755n 0.0v 819.745n 0.0v 819.755n 0.0v 824.745n 0.0v 824.755n 0.0v 829.745n 0.0v 829.755n 0.0v 834.745n 0.0v 834.755n 0.0v 839.745n 0.0v 839.755n 0.0v 844.745n 0.0v 844.755n 0.0v 849.745n 0.0v 849.755n 0.0v 854.745n 0.0v 854.755n 0.0v 859.745n 0.0v 859.755n 0.0v 864.745n 0.0v 864.755n 0.0v 869.745n 0.0v 869.755n 0.0v 874.745n 0.0v 874.755n 0.0v 879.745n 0.0v 879.755n 0.0v 884.745n 0.0v 884.755n 0.0v 889.745n 0.0v 889.755n 0.0v 894.745n 0.0v 894.755n 0.0v 899.745n 0.0v 899.755n 0.0v 904.745n 0.0v 904.755n 0.0v 909.745n 0.0v 909.755n 0.0v 914.745n 0.0v 914.755n 0.0v 919.745n 0.0v 919.755n 1.1v 924.745n 1.1v 924.755n 1.1v 929.745n 1.1v 929.755n 1.1v 934.745n 1.1v 934.755n 1.1v 939.745n 1.1v 939.755n 1.1v 944.745n 1.1v 944.755n 1.1v 949.745n 1.1v 949.755n 1.1v 954.745n 1.1v 954.755n 1.1v 959.745n 1.1v 959.755n 1.1v 964.745n 1.1v 964.755n 1.1v 969.745n 1.1v 969.755n 1.1v 974.745n 1.1v 974.755n 1.1v 979.745n 1.1v 979.755n 1.1v 984.745n 1.1v 984.755n 0.0v 989.745n 0.0v 989.755n 0.0v 994.745n 0.0v 994.755n 0.0v 999.745n 0.0v 999.755n 0.0v 1004.745n 0.0v 1004.755n 0.0v 1009.745n 0.0v 1009.755n 0.0v 1014.745n 0.0v 1014.755n 0.0v 1019.745n 0.0v 1019.755n 1.1v 1024.745n 1.1v 1024.755n 1.1v )
* (time, data): [(0, 0), (5, 1), (10, 0), (15, 1), (20, 1), (25, 1), (30, 0), (35, 0), (40, 0), (45, 0), (50, 0), (55, 0), (60, 0), (65, 0), (70, 0), (75, 0), (80, 0), (85, 0), (90, 0), (95, 0), (100, 1), (105, 1), (110, 1), (115, 0), (120, 0), (125, 0), (130, 0), (135, 1), (140, 0), (145, 0), (150, 0), (155, 0), (160, 0), (165, 1), (170, 1), (175, 1), (180, 1), (185, 1), (190, 1), (195, 1), (200, 0), (205, 0), (210, 0), (215, 0), (220, 1), (225, 1), (230, 0), (235, 0), (240, 0), (245, 1), (250, 1), (255, 0), (260, 0), (265, 0), (270, 1), (275, 1), (280, 1), (285, 0), (290, 0), (295, 0), (300, 0), (305, 1), (310, 1), (315, 1), (320, 1), (325, 0), (330, 0), (335, 0), (340, 0), (345, 1), (350, 1), (355, 1), (360, 1), (365, 1), (370, 1), (375, 1), (380, 1), (385, 1), (390, 1), (395, 1), (400, 1), (405, 1), (410, 1), (415, 0), (420, 0), (425, 0), (430, 0), (435, 0), (440, 0), (445, 0), (450, 0), (455, 0), (460, 0), (465, 0), (470, 0), (475, 0), (480, 1), (485, 0), (490, 0), (495, 0), (500, 0), (505, 0), (510, 0), (515, 0), (520, 1), (525, 1), (530, 1), (535, 0), (540, 0), (545, 0), (550, 0), (555, 1), (560, 1), (565, 1), (570, 0), (575, 0), (580, 0), (585, 0), (590, 0), (595, 0), (600, 0), (605, 0), (610, 0), (615, 0), (620, 0), (625, 0), (630, 0), (635, 0), (640, 0), (645, 0), (650, 1), (655, 0), (660, 0), (665, 0), (670, 0), (675, 0), (680, 0), (685, 0), (690, 0), (695, 0), (700, 0), (705, 0), (710, 0), (715, 1), (720, 1), (725, 0), (730, 0), (735, 0), (740, 0), (745, 0), (750, 0), (755, 0), (760, 0), (765, 0), (770, 0), (775, 0), (780, 0), (785, 0), (790, 0), (795, 1), (800, 1), (805, 1), (810, 1), (815, 1), (820, 1), (825, 1), (830, 1), (835, 1), (840, 0), (845, 0), (850, 0), (855, 0), (860, 0), (865, 0), (870, 1), (875, 1), (880, 1), (885, 1), (890, 1), (895, 1), (900, 1), (905, 1), (910, 1), (915, 1), (920, 1), (925, 1), (930, 1), (935, 1), (940, 1), (945, 1), (950, 1), (955, 1), (960, 1), (965, 1), (970, 1), (975, 1), (980, 1), (985, 0), (990, 1), (995, 1), (1000, 1), (1005, 1), (1010, 1), (1015, 0), (1020, 0), (1025, 0)]
Vdin0_17  din0_17  0 PWL (0n 0.0v 4.745n 0.0v 4.755n 1.1v 9.745n 1.1v 9.755n 0.0v 14.745n 0.0v 14.755n 1.1v 19.745n 1.1v 19.755n 1.1v 24.745n 1.1v 24.755n 1.1v 29.745n 1.1v 29.755n 0.0v 34.745n 0.0v 34.755n 0.0v 39.745n 0.0v 39.755n 0.0v 44.745n 0.0v 44.755n 0.0v 49.745n 0.0v 49.755n 0.0v 54.745n 0.0v 54.755n 0.0v 59.745n 0.0v 59.755n 0.0v 64.745n 0.0v 64.755n 0.0v 69.745n 0.0v 69.755n 0.0v 74.745n 0.0v 74.755n 0.0v 79.745n 0.0v 79.755n 0.0v 84.745n 0.0v 84.755n 0.0v 89.745n 0.0v 89.755n 0.0v 94.745n 0.0v 94.755n 0.0v 99.745n 0.0v 99.755n 1.1v 104.745n 1.1v 104.755n 1.1v 109.745n 1.1v 109.755n 1.1v 114.745n 1.1v 114.755n 0.0v 119.745n 0.0v 119.755n 0.0v 124.745n 0.0v 124.755n 0.0v 129.745n 0.0v 129.755n 0.0v 134.745n 0.0v 134.755n 1.1v 139.745n 1.1v 139.755n 0.0v 144.745n 0.0v 144.755n 0.0v 149.745n 0.0v 149.755n 0.0v 154.745n 0.0v 154.755n 0.0v 159.745n 0.0v 159.755n 0.0v 164.745n 0.0v 164.755n 1.1v 169.745n 1.1v 169.755n 1.1v 174.745n 1.1v 174.755n 1.1v 179.745n 1.1v 179.755n 1.1v 184.745n 1.1v 184.755n 1.1v 189.745n 1.1v 189.755n 1.1v 194.745n 1.1v 194.755n 1.1v 199.745n 1.1v 199.755n 0.0v 204.745n 0.0v 204.755n 0.0v 209.745n 0.0v 209.755n 0.0v 214.745n 0.0v 214.755n 0.0v 219.745n 0.0v 219.755n 1.1v 224.745n 1.1v 224.755n 1.1v 229.745n 1.1v 229.755n 0.0v 234.745n 0.0v 234.755n 0.0v 239.745n 0.0v 239.755n 0.0v 244.745n 0.0v 244.755n 1.1v 249.745n 1.1v 249.755n 1.1v 254.745n 1.1v 254.755n 0.0v 259.745n 0.0v 259.755n 0.0v 264.745n 0.0v 264.755n 0.0v 269.745n 0.0v 269.755n 1.1v 274.745n 1.1v 274.755n 1.1v 279.745n 1.1v 279.755n 1.1v 284.745n 1.1v 284.755n 0.0v 289.745n 0.0v 289.755n 0.0v 294.745n 0.0v 294.755n 0.0v 299.745n 0.0v 299.755n 0.0v 304.745n 0.0v 304.755n 1.1v 309.745n 1.1v 309.755n 1.1v 314.745n 1.1v 314.755n 1.1v 319.745n 1.1v 319.755n 1.1v 324.745n 1.1v 324.755n 0.0v 329.745n 0.0v 329.755n 0.0v 334.745n 0.0v 334.755n 0.0v 339.745n 0.0v 339.755n 0.0v 344.745n 0.0v 344.755n 1.1v 349.745n 1.1v 349.755n 1.1v 354.745n 1.1v 354.755n 1.1v 359.745n 1.1v 359.755n 1.1v 364.745n 1.1v 364.755n 1.1v 369.745n 1.1v 369.755n 1.1v 374.745n 1.1v 374.755n 1.1v 379.745n 1.1v 379.755n 1.1v 384.745n 1.1v 384.755n 1.1v 389.745n 1.1v 389.755n 1.1v 394.745n 1.1v 394.755n 1.1v 399.745n 1.1v 399.755n 1.1v 404.745n 1.1v 404.755n 1.1v 409.745n 1.1v 409.755n 1.1v 414.745n 1.1v 414.755n 0.0v 419.745n 0.0v 419.755n 0.0v 424.745n 0.0v 424.755n 0.0v 429.745n 0.0v 429.755n 0.0v 434.745n 0.0v 434.755n 0.0v 439.745n 0.0v 439.755n 0.0v 444.745n 0.0v 444.755n 0.0v 449.745n 0.0v 449.755n 0.0v 454.745n 0.0v 454.755n 0.0v 459.745n 0.0v 459.755n 0.0v 464.745n 0.0v 464.755n 0.0v 469.745n 0.0v 469.755n 0.0v 474.745n 0.0v 474.755n 0.0v 479.745n 0.0v 479.755n 1.1v 484.745n 1.1v 484.755n 0.0v 489.745n 0.0v 489.755n 0.0v 494.745n 0.0v 494.755n 0.0v 499.745n 0.0v 499.755n 0.0v 504.745n 0.0v 504.755n 0.0v 509.745n 0.0v 509.755n 0.0v 514.745n 0.0v 514.755n 0.0v 519.745n 0.0v 519.755n 1.1v 524.745n 1.1v 524.755n 1.1v 529.745n 1.1v 529.755n 1.1v 534.745n 1.1v 534.755n 0.0v 539.745n 0.0v 539.755n 0.0v 544.745n 0.0v 544.755n 0.0v 549.745n 0.0v 549.755n 0.0v 554.745n 0.0v 554.755n 1.1v 559.745n 1.1v 559.755n 1.1v 564.745n 1.1v 564.755n 1.1v 569.745n 1.1v 569.755n 0.0v 574.745n 0.0v 574.755n 0.0v 579.745n 0.0v 579.755n 0.0v 584.745n 0.0v 584.755n 0.0v 589.745n 0.0v 589.755n 0.0v 594.745n 0.0v 594.755n 0.0v 599.745n 0.0v 599.755n 0.0v 604.745n 0.0v 604.755n 0.0v 609.745n 0.0v 609.755n 0.0v 614.745n 0.0v 614.755n 0.0v 619.745n 0.0v 619.755n 0.0v 624.745n 0.0v 624.755n 0.0v 629.745n 0.0v 629.755n 0.0v 634.745n 0.0v 634.755n 0.0v 639.745n 0.0v 639.755n 0.0v 644.745n 0.0v 644.755n 0.0v 649.745n 0.0v 649.755n 1.1v 654.745n 1.1v 654.755n 0.0v 659.745n 0.0v 659.755n 0.0v 664.745n 0.0v 664.755n 0.0v 669.745n 0.0v 669.755n 0.0v 674.745n 0.0v 674.755n 0.0v 679.745n 0.0v 679.755n 0.0v 684.745n 0.0v 684.755n 0.0v 689.745n 0.0v 689.755n 0.0v 694.745n 0.0v 694.755n 0.0v 699.745n 0.0v 699.755n 0.0v 704.745n 0.0v 704.755n 0.0v 709.745n 0.0v 709.755n 0.0v 714.745n 0.0v 714.755n 1.1v 719.745n 1.1v 719.755n 1.1v 724.745n 1.1v 724.755n 0.0v 729.745n 0.0v 729.755n 0.0v 734.745n 0.0v 734.755n 0.0v 739.745n 0.0v 739.755n 0.0v 744.745n 0.0v 744.755n 0.0v 749.745n 0.0v 749.755n 0.0v 754.745n 0.0v 754.755n 0.0v 759.745n 0.0v 759.755n 0.0v 764.745n 0.0v 764.755n 0.0v 769.745n 0.0v 769.755n 0.0v 774.745n 0.0v 774.755n 0.0v 779.745n 0.0v 779.755n 0.0v 784.745n 0.0v 784.755n 0.0v 789.745n 0.0v 789.755n 0.0v 794.745n 0.0v 794.755n 1.1v 799.745n 1.1v 799.755n 1.1v 804.745n 1.1v 804.755n 1.1v 809.745n 1.1v 809.755n 1.1v 814.745n 1.1v 814.755n 1.1v 819.745n 1.1v 819.755n 1.1v 824.745n 1.1v 824.755n 1.1v 829.745n 1.1v 829.755n 1.1v 834.745n 1.1v 834.755n 1.1v 839.745n 1.1v 839.755n 0.0v 844.745n 0.0v 844.755n 0.0v 849.745n 0.0v 849.755n 0.0v 854.745n 0.0v 854.755n 0.0v 859.745n 0.0v 859.755n 0.0v 864.745n 0.0v 864.755n 0.0v 869.745n 0.0v 869.755n 1.1v 874.745n 1.1v 874.755n 1.1v 879.745n 1.1v 879.755n 1.1v 884.745n 1.1v 884.755n 1.1v 889.745n 1.1v 889.755n 1.1v 894.745n 1.1v 894.755n 1.1v 899.745n 1.1v 899.755n 1.1v 904.745n 1.1v 904.755n 1.1v 909.745n 1.1v 909.755n 1.1v 914.745n 1.1v 914.755n 1.1v 919.745n 1.1v 919.755n 1.1v 924.745n 1.1v 924.755n 1.1v 929.745n 1.1v 929.755n 1.1v 934.745n 1.1v 934.755n 1.1v 939.745n 1.1v 939.755n 1.1v 944.745n 1.1v 944.755n 1.1v 949.745n 1.1v 949.755n 1.1v 954.745n 1.1v 954.755n 1.1v 959.745n 1.1v 959.755n 1.1v 964.745n 1.1v 964.755n 1.1v 969.745n 1.1v 969.755n 1.1v 974.745n 1.1v 974.755n 1.1v 979.745n 1.1v 979.755n 1.1v 984.745n 1.1v 984.755n 0.0v 989.745n 0.0v 989.755n 1.1v 994.745n 1.1v 994.755n 1.1v 999.745n 1.1v 999.755n 1.1v 1004.745n 1.1v 1004.755n 1.1v 1009.745n 1.1v 1009.755n 1.1v 1014.745n 1.1v 1014.755n 0.0v 1019.745n 0.0v 1019.755n 0.0v 1024.745n 0.0v 1024.755n 0.0v )
* (time, data): [(0, 0), (5, 1), (10, 0), (15, 1), (20, 1), (25, 1), (30, 1), (35, 1), (40, 1), (45, 1), (50, 1), (55, 1), (60, 1), (65, 1), (70, 1), (75, 1), (80, 1), (85, 1), (90, 1), (95, 1), (100, 1), (105, 1), (110, 1), (115, 1), (120, 1), (125, 0), (130, 0), (135, 0), (140, 1), (145, 0), (150, 0), (155, 0), (160, 0), (165, 1), (170, 1), (175, 1), (180, 1), (185, 1), (190, 1), (195, 1), (200, 1), (205, 1), (210, 1), (215, 1), (220, 0), (225, 0), (230, 1), (235, 1), (240, 1), (245, 1), (250, 1), (255, 1), (260, 1), (265, 1), (270, 0), (275, 0), (280, 0), (285, 1), (290, 1), (295, 1), (300, 1), (305, 1), (310, 1), (315, 1), (320, 1), (325, 0), (330, 1), (335, 1), (340, 1), (345, 1), (350, 1), (355, 1), (360, 1), (365, 1), (370, 1), (375, 1), (380, 1), (385, 1), (390, 1), (395, 1), (400, 1), (405, 1), (410, 1), (415, 0), (420, 1), (425, 1), (430, 0), (435, 0), (440, 0), (445, 0), (450, 0), (455, 0), (460, 0), (465, 0), (470, 0), (475, 0), (480, 0), (485, 0), (490, 0), (495, 0), (500, 0), (505, 0), (510, 0), (515, 0), (520, 1), (525, 1), (530, 1), (535, 1), (540, 0), (545, 0), (550, 0), (555, 0), (560, 0), (565, 0), (570, 0), (575, 0), (580, 0), (585, 1), (590, 1), (595, 1), (600, 0), (605, 0), (610, 0), (615, 0), (620, 0), (625, 0), (630, 0), (635, 0), (640, 0), (645, 0), (650, 1), (655, 0), (660, 0), (665, 0), (670, 0), (675, 0), (680, 0), (685, 0), (690, 1), (695, 1), (700, 1), (705, 1), (710, 1), (715, 1), (720, 1), (725, 1), (730, 1), (735, 1), (740, 1), (745, 1), (750, 1), (755, 1), (760, 1), (765, 1), (770, 1), (775, 1), (780, 1), (785, 1), (790, 1), (795, 1), (800, 1), (805, 1), (810, 1), (815, 1), (820, 1), (825, 1), (830, 1), (835, 1), (840, 1), (845, 1), (850, 1), (855, 1), (860, 1), (865, 1), (870, 1), (875, 1), (880, 1), (885, 1), (890, 1), (895, 0), (900, 0), (905, 0), (910, 0), (915, 0), (920, 0), (925, 0), (930, 0), (935, 0), (940, 0), (945, 0), (950, 0), (955, 0), (960, 0), (965, 0), (970, 0), (975, 0), (980, 0), (985, 0), (990, 1), (995, 1), (1000, 1), (1005, 1), (1010, 1), (1015, 0), (1020, 1), (1025, 1)]
Vdin0_18  din0_18  0 PWL (0n 0.0v 4.745n 0.0v 4.755n 1.1v 9.745n 1.1v 9.755n 0.0v 14.745n 0.0v 14.755n 1.1v 19.745n 1.1v 19.755n 1.1v 24.745n 1.1v 24.755n 1.1v 29.745n 1.1v 29.755n 1.1v 34.745n 1.1v 34.755n 1.1v 39.745n 1.1v 39.755n 1.1v 44.745n 1.1v 44.755n 1.1v 49.745n 1.1v 49.755n 1.1v 54.745n 1.1v 54.755n 1.1v 59.745n 1.1v 59.755n 1.1v 64.745n 1.1v 64.755n 1.1v 69.745n 1.1v 69.755n 1.1v 74.745n 1.1v 74.755n 1.1v 79.745n 1.1v 79.755n 1.1v 84.745n 1.1v 84.755n 1.1v 89.745n 1.1v 89.755n 1.1v 94.745n 1.1v 94.755n 1.1v 99.745n 1.1v 99.755n 1.1v 104.745n 1.1v 104.755n 1.1v 109.745n 1.1v 109.755n 1.1v 114.745n 1.1v 114.755n 1.1v 119.745n 1.1v 119.755n 1.1v 124.745n 1.1v 124.755n 0.0v 129.745n 0.0v 129.755n 0.0v 134.745n 0.0v 134.755n 0.0v 139.745n 0.0v 139.755n 1.1v 144.745n 1.1v 144.755n 0.0v 149.745n 0.0v 149.755n 0.0v 154.745n 0.0v 154.755n 0.0v 159.745n 0.0v 159.755n 0.0v 164.745n 0.0v 164.755n 1.1v 169.745n 1.1v 169.755n 1.1v 174.745n 1.1v 174.755n 1.1v 179.745n 1.1v 179.755n 1.1v 184.745n 1.1v 184.755n 1.1v 189.745n 1.1v 189.755n 1.1v 194.745n 1.1v 194.755n 1.1v 199.745n 1.1v 199.755n 1.1v 204.745n 1.1v 204.755n 1.1v 209.745n 1.1v 209.755n 1.1v 214.745n 1.1v 214.755n 1.1v 219.745n 1.1v 219.755n 0.0v 224.745n 0.0v 224.755n 0.0v 229.745n 0.0v 229.755n 1.1v 234.745n 1.1v 234.755n 1.1v 239.745n 1.1v 239.755n 1.1v 244.745n 1.1v 244.755n 1.1v 249.745n 1.1v 249.755n 1.1v 254.745n 1.1v 254.755n 1.1v 259.745n 1.1v 259.755n 1.1v 264.745n 1.1v 264.755n 1.1v 269.745n 1.1v 269.755n 0.0v 274.745n 0.0v 274.755n 0.0v 279.745n 0.0v 279.755n 0.0v 284.745n 0.0v 284.755n 1.1v 289.745n 1.1v 289.755n 1.1v 294.745n 1.1v 294.755n 1.1v 299.745n 1.1v 299.755n 1.1v 304.745n 1.1v 304.755n 1.1v 309.745n 1.1v 309.755n 1.1v 314.745n 1.1v 314.755n 1.1v 319.745n 1.1v 319.755n 1.1v 324.745n 1.1v 324.755n 0.0v 329.745n 0.0v 329.755n 1.1v 334.745n 1.1v 334.755n 1.1v 339.745n 1.1v 339.755n 1.1v 344.745n 1.1v 344.755n 1.1v 349.745n 1.1v 349.755n 1.1v 354.745n 1.1v 354.755n 1.1v 359.745n 1.1v 359.755n 1.1v 364.745n 1.1v 364.755n 1.1v 369.745n 1.1v 369.755n 1.1v 374.745n 1.1v 374.755n 1.1v 379.745n 1.1v 379.755n 1.1v 384.745n 1.1v 384.755n 1.1v 389.745n 1.1v 389.755n 1.1v 394.745n 1.1v 394.755n 1.1v 399.745n 1.1v 399.755n 1.1v 404.745n 1.1v 404.755n 1.1v 409.745n 1.1v 409.755n 1.1v 414.745n 1.1v 414.755n 0.0v 419.745n 0.0v 419.755n 1.1v 424.745n 1.1v 424.755n 1.1v 429.745n 1.1v 429.755n 0.0v 434.745n 0.0v 434.755n 0.0v 439.745n 0.0v 439.755n 0.0v 444.745n 0.0v 444.755n 0.0v 449.745n 0.0v 449.755n 0.0v 454.745n 0.0v 454.755n 0.0v 459.745n 0.0v 459.755n 0.0v 464.745n 0.0v 464.755n 0.0v 469.745n 0.0v 469.755n 0.0v 474.745n 0.0v 474.755n 0.0v 479.745n 0.0v 479.755n 0.0v 484.745n 0.0v 484.755n 0.0v 489.745n 0.0v 489.755n 0.0v 494.745n 0.0v 494.755n 0.0v 499.745n 0.0v 499.755n 0.0v 504.745n 0.0v 504.755n 0.0v 509.745n 0.0v 509.755n 0.0v 514.745n 0.0v 514.755n 0.0v 519.745n 0.0v 519.755n 1.1v 524.745n 1.1v 524.755n 1.1v 529.745n 1.1v 529.755n 1.1v 534.745n 1.1v 534.755n 1.1v 539.745n 1.1v 539.755n 0.0v 544.745n 0.0v 544.755n 0.0v 549.745n 0.0v 549.755n 0.0v 554.745n 0.0v 554.755n 0.0v 559.745n 0.0v 559.755n 0.0v 564.745n 0.0v 564.755n 0.0v 569.745n 0.0v 569.755n 0.0v 574.745n 0.0v 574.755n 0.0v 579.745n 0.0v 579.755n 0.0v 584.745n 0.0v 584.755n 1.1v 589.745n 1.1v 589.755n 1.1v 594.745n 1.1v 594.755n 1.1v 599.745n 1.1v 599.755n 0.0v 604.745n 0.0v 604.755n 0.0v 609.745n 0.0v 609.755n 0.0v 614.745n 0.0v 614.755n 0.0v 619.745n 0.0v 619.755n 0.0v 624.745n 0.0v 624.755n 0.0v 629.745n 0.0v 629.755n 0.0v 634.745n 0.0v 634.755n 0.0v 639.745n 0.0v 639.755n 0.0v 644.745n 0.0v 644.755n 0.0v 649.745n 0.0v 649.755n 1.1v 654.745n 1.1v 654.755n 0.0v 659.745n 0.0v 659.755n 0.0v 664.745n 0.0v 664.755n 0.0v 669.745n 0.0v 669.755n 0.0v 674.745n 0.0v 674.755n 0.0v 679.745n 0.0v 679.755n 0.0v 684.745n 0.0v 684.755n 0.0v 689.745n 0.0v 689.755n 1.1v 694.745n 1.1v 694.755n 1.1v 699.745n 1.1v 699.755n 1.1v 704.745n 1.1v 704.755n 1.1v 709.745n 1.1v 709.755n 1.1v 714.745n 1.1v 714.755n 1.1v 719.745n 1.1v 719.755n 1.1v 724.745n 1.1v 724.755n 1.1v 729.745n 1.1v 729.755n 1.1v 734.745n 1.1v 734.755n 1.1v 739.745n 1.1v 739.755n 1.1v 744.745n 1.1v 744.755n 1.1v 749.745n 1.1v 749.755n 1.1v 754.745n 1.1v 754.755n 1.1v 759.745n 1.1v 759.755n 1.1v 764.745n 1.1v 764.755n 1.1v 769.745n 1.1v 769.755n 1.1v 774.745n 1.1v 774.755n 1.1v 779.745n 1.1v 779.755n 1.1v 784.745n 1.1v 784.755n 1.1v 789.745n 1.1v 789.755n 1.1v 794.745n 1.1v 794.755n 1.1v 799.745n 1.1v 799.755n 1.1v 804.745n 1.1v 804.755n 1.1v 809.745n 1.1v 809.755n 1.1v 814.745n 1.1v 814.755n 1.1v 819.745n 1.1v 819.755n 1.1v 824.745n 1.1v 824.755n 1.1v 829.745n 1.1v 829.755n 1.1v 834.745n 1.1v 834.755n 1.1v 839.745n 1.1v 839.755n 1.1v 844.745n 1.1v 844.755n 1.1v 849.745n 1.1v 849.755n 1.1v 854.745n 1.1v 854.755n 1.1v 859.745n 1.1v 859.755n 1.1v 864.745n 1.1v 864.755n 1.1v 869.745n 1.1v 869.755n 1.1v 874.745n 1.1v 874.755n 1.1v 879.745n 1.1v 879.755n 1.1v 884.745n 1.1v 884.755n 1.1v 889.745n 1.1v 889.755n 1.1v 894.745n 1.1v 894.755n 0.0v 899.745n 0.0v 899.755n 0.0v 904.745n 0.0v 904.755n 0.0v 909.745n 0.0v 909.755n 0.0v 914.745n 0.0v 914.755n 0.0v 919.745n 0.0v 919.755n 0.0v 924.745n 0.0v 924.755n 0.0v 929.745n 0.0v 929.755n 0.0v 934.745n 0.0v 934.755n 0.0v 939.745n 0.0v 939.755n 0.0v 944.745n 0.0v 944.755n 0.0v 949.745n 0.0v 949.755n 0.0v 954.745n 0.0v 954.755n 0.0v 959.745n 0.0v 959.755n 0.0v 964.745n 0.0v 964.755n 0.0v 969.745n 0.0v 969.755n 0.0v 974.745n 0.0v 974.755n 0.0v 979.745n 0.0v 979.755n 0.0v 984.745n 0.0v 984.755n 0.0v 989.745n 0.0v 989.755n 1.1v 994.745n 1.1v 994.755n 1.1v 999.745n 1.1v 999.755n 1.1v 1004.745n 1.1v 1004.755n 1.1v 1009.745n 1.1v 1009.755n 1.1v 1014.745n 1.1v 1014.755n 0.0v 1019.745n 0.0v 1019.755n 1.1v 1024.745n 1.1v 1024.755n 1.1v )
* (time, data): [(0, 0), (5, 1), (10, 1), (15, 0), (20, 0), (25, 0), (30, 1), (35, 0), (40, 1), (45, 1), (50, 1), (55, 1), (60, 0), (65, 0), (70, 0), (75, 0), (80, 0), (85, 0), (90, 0), (95, 0), (100, 0), (105, 0), (110, 0), (115, 0), (120, 0), (125, 1), (130, 1), (135, 1), (140, 1), (145, 1), (150, 1), (155, 1), (160, 1), (165, 0), (170, 0), (175, 0), (180, 0), (185, 0), (190, 0), (195, 0), (200, 0), (205, 0), (210, 0), (215, 0), (220, 1), (225, 1), (230, 1), (235, 1), (240, 1), (245, 0), (250, 0), (255, 1), (260, 1), (265, 1), (270, 0), (275, 0), (280, 0), (285, 1), (290, 1), (295, 1), (300, 1), (305, 0), (310, 0), (315, 0), (320, 0), (325, 1), (330, 1), (335, 1), (340, 1), (345, 1), (350, 1), (355, 1), (360, 1), (365, 1), (370, 1), (375, 0), (380, 0), (385, 1), (390, 1), (395, 1), (400, 1), (405, 1), (410, 1), (415, 0), (420, 0), (425, 0), (430, 0), (435, 0), (440, 0), (445, 0), (450, 0), (455, 0), (460, 0), (465, 0), (470, 0), (475, 0), (480, 1), (485, 0), (490, 0), (495, 1), (500, 1), (505, 1), (510, 1), (515, 1), (520, 0), (525, 0), (530, 0), (535, 1), (540, 0), (545, 0), (550, 0), (555, 0), (560, 0), (565, 0), (570, 0), (575, 0), (580, 0), (585, 0), (590, 0), (595, 0), (600, 0), (605, 0), (610, 0), (615, 0), (620, 0), (625, 0), (630, 0), (635, 0), (640, 0), (645, 0), (650, 1), (655, 1), (660, 1), (665, 1), (670, 1), (675, 1), (680, 1), (685, 1), (690, 0), (695, 0), (700, 0), (705, 0), (710, 0), (715, 0), (720, 0), (725, 1), (730, 1), (735, 1), (740, 1), (745, 1), (750, 1), (755, 1), (760, 1), (765, 1), (770, 1), (775, 1), (780, 1), (785, 1), (790, 1), (795, 0), (800, 0), (805, 0), (810, 0), (815, 0), (820, 0), (825, 0), (830, 0), (835, 0), (840, 1), (845, 1), (850, 1), (855, 1), (860, 1), (865, 1), (870, 0), (875, 0), (880, 0), (885, 0), (890, 0), (895, 0), (900, 0), (905, 0), (910, 0), (915, 0), (920, 0), (925, 0), (930, 0), (935, 0), (940, 1), (945, 1), (950, 1), (955, 1), (960, 1), (965, 1), (970, 1), (975, 1), (980, 1), (985, 0), (990, 1), (995, 1), (1000, 1), (1005, 1), (1010, 1), (1015, 1), (1020, 0), (1025, 0)]
Vdin0_19  din0_19  0 PWL (0n 0.0v 4.745n 0.0v 4.755n 1.1v 9.745n 1.1v 9.755n 1.1v 14.745n 1.1v 14.755n 0.0v 19.745n 0.0v 19.755n 0.0v 24.745n 0.0v 24.755n 0.0v 29.745n 0.0v 29.755n 1.1v 34.745n 1.1v 34.755n 0.0v 39.745n 0.0v 39.755n 1.1v 44.745n 1.1v 44.755n 1.1v 49.745n 1.1v 49.755n 1.1v 54.745n 1.1v 54.755n 1.1v 59.745n 1.1v 59.755n 0.0v 64.745n 0.0v 64.755n 0.0v 69.745n 0.0v 69.755n 0.0v 74.745n 0.0v 74.755n 0.0v 79.745n 0.0v 79.755n 0.0v 84.745n 0.0v 84.755n 0.0v 89.745n 0.0v 89.755n 0.0v 94.745n 0.0v 94.755n 0.0v 99.745n 0.0v 99.755n 0.0v 104.745n 0.0v 104.755n 0.0v 109.745n 0.0v 109.755n 0.0v 114.745n 0.0v 114.755n 0.0v 119.745n 0.0v 119.755n 0.0v 124.745n 0.0v 124.755n 1.1v 129.745n 1.1v 129.755n 1.1v 134.745n 1.1v 134.755n 1.1v 139.745n 1.1v 139.755n 1.1v 144.745n 1.1v 144.755n 1.1v 149.745n 1.1v 149.755n 1.1v 154.745n 1.1v 154.755n 1.1v 159.745n 1.1v 159.755n 1.1v 164.745n 1.1v 164.755n 0.0v 169.745n 0.0v 169.755n 0.0v 174.745n 0.0v 174.755n 0.0v 179.745n 0.0v 179.755n 0.0v 184.745n 0.0v 184.755n 0.0v 189.745n 0.0v 189.755n 0.0v 194.745n 0.0v 194.755n 0.0v 199.745n 0.0v 199.755n 0.0v 204.745n 0.0v 204.755n 0.0v 209.745n 0.0v 209.755n 0.0v 214.745n 0.0v 214.755n 0.0v 219.745n 0.0v 219.755n 1.1v 224.745n 1.1v 224.755n 1.1v 229.745n 1.1v 229.755n 1.1v 234.745n 1.1v 234.755n 1.1v 239.745n 1.1v 239.755n 1.1v 244.745n 1.1v 244.755n 0.0v 249.745n 0.0v 249.755n 0.0v 254.745n 0.0v 254.755n 1.1v 259.745n 1.1v 259.755n 1.1v 264.745n 1.1v 264.755n 1.1v 269.745n 1.1v 269.755n 0.0v 274.745n 0.0v 274.755n 0.0v 279.745n 0.0v 279.755n 0.0v 284.745n 0.0v 284.755n 1.1v 289.745n 1.1v 289.755n 1.1v 294.745n 1.1v 294.755n 1.1v 299.745n 1.1v 299.755n 1.1v 304.745n 1.1v 304.755n 0.0v 309.745n 0.0v 309.755n 0.0v 314.745n 0.0v 314.755n 0.0v 319.745n 0.0v 319.755n 0.0v 324.745n 0.0v 324.755n 1.1v 329.745n 1.1v 329.755n 1.1v 334.745n 1.1v 334.755n 1.1v 339.745n 1.1v 339.755n 1.1v 344.745n 1.1v 344.755n 1.1v 349.745n 1.1v 349.755n 1.1v 354.745n 1.1v 354.755n 1.1v 359.745n 1.1v 359.755n 1.1v 364.745n 1.1v 364.755n 1.1v 369.745n 1.1v 369.755n 1.1v 374.745n 1.1v 374.755n 0.0v 379.745n 0.0v 379.755n 0.0v 384.745n 0.0v 384.755n 1.1v 389.745n 1.1v 389.755n 1.1v 394.745n 1.1v 394.755n 1.1v 399.745n 1.1v 399.755n 1.1v 404.745n 1.1v 404.755n 1.1v 409.745n 1.1v 409.755n 1.1v 414.745n 1.1v 414.755n 0.0v 419.745n 0.0v 419.755n 0.0v 424.745n 0.0v 424.755n 0.0v 429.745n 0.0v 429.755n 0.0v 434.745n 0.0v 434.755n 0.0v 439.745n 0.0v 439.755n 0.0v 444.745n 0.0v 444.755n 0.0v 449.745n 0.0v 449.755n 0.0v 454.745n 0.0v 454.755n 0.0v 459.745n 0.0v 459.755n 0.0v 464.745n 0.0v 464.755n 0.0v 469.745n 0.0v 469.755n 0.0v 474.745n 0.0v 474.755n 0.0v 479.745n 0.0v 479.755n 1.1v 484.745n 1.1v 484.755n 0.0v 489.745n 0.0v 489.755n 0.0v 494.745n 0.0v 494.755n 1.1v 499.745n 1.1v 499.755n 1.1v 504.745n 1.1v 504.755n 1.1v 509.745n 1.1v 509.755n 1.1v 514.745n 1.1v 514.755n 1.1v 519.745n 1.1v 519.755n 0.0v 524.745n 0.0v 524.755n 0.0v 529.745n 0.0v 529.755n 0.0v 534.745n 0.0v 534.755n 1.1v 539.745n 1.1v 539.755n 0.0v 544.745n 0.0v 544.755n 0.0v 549.745n 0.0v 549.755n 0.0v 554.745n 0.0v 554.755n 0.0v 559.745n 0.0v 559.755n 0.0v 564.745n 0.0v 564.755n 0.0v 569.745n 0.0v 569.755n 0.0v 574.745n 0.0v 574.755n 0.0v 579.745n 0.0v 579.755n 0.0v 584.745n 0.0v 584.755n 0.0v 589.745n 0.0v 589.755n 0.0v 594.745n 0.0v 594.755n 0.0v 599.745n 0.0v 599.755n 0.0v 604.745n 0.0v 604.755n 0.0v 609.745n 0.0v 609.755n 0.0v 614.745n 0.0v 614.755n 0.0v 619.745n 0.0v 619.755n 0.0v 624.745n 0.0v 624.755n 0.0v 629.745n 0.0v 629.755n 0.0v 634.745n 0.0v 634.755n 0.0v 639.745n 0.0v 639.755n 0.0v 644.745n 0.0v 644.755n 0.0v 649.745n 0.0v 649.755n 1.1v 654.745n 1.1v 654.755n 1.1v 659.745n 1.1v 659.755n 1.1v 664.745n 1.1v 664.755n 1.1v 669.745n 1.1v 669.755n 1.1v 674.745n 1.1v 674.755n 1.1v 679.745n 1.1v 679.755n 1.1v 684.745n 1.1v 684.755n 1.1v 689.745n 1.1v 689.755n 0.0v 694.745n 0.0v 694.755n 0.0v 699.745n 0.0v 699.755n 0.0v 704.745n 0.0v 704.755n 0.0v 709.745n 0.0v 709.755n 0.0v 714.745n 0.0v 714.755n 0.0v 719.745n 0.0v 719.755n 0.0v 724.745n 0.0v 724.755n 1.1v 729.745n 1.1v 729.755n 1.1v 734.745n 1.1v 734.755n 1.1v 739.745n 1.1v 739.755n 1.1v 744.745n 1.1v 744.755n 1.1v 749.745n 1.1v 749.755n 1.1v 754.745n 1.1v 754.755n 1.1v 759.745n 1.1v 759.755n 1.1v 764.745n 1.1v 764.755n 1.1v 769.745n 1.1v 769.755n 1.1v 774.745n 1.1v 774.755n 1.1v 779.745n 1.1v 779.755n 1.1v 784.745n 1.1v 784.755n 1.1v 789.745n 1.1v 789.755n 1.1v 794.745n 1.1v 794.755n 0.0v 799.745n 0.0v 799.755n 0.0v 804.745n 0.0v 804.755n 0.0v 809.745n 0.0v 809.755n 0.0v 814.745n 0.0v 814.755n 0.0v 819.745n 0.0v 819.755n 0.0v 824.745n 0.0v 824.755n 0.0v 829.745n 0.0v 829.755n 0.0v 834.745n 0.0v 834.755n 0.0v 839.745n 0.0v 839.755n 1.1v 844.745n 1.1v 844.755n 1.1v 849.745n 1.1v 849.755n 1.1v 854.745n 1.1v 854.755n 1.1v 859.745n 1.1v 859.755n 1.1v 864.745n 1.1v 864.755n 1.1v 869.745n 1.1v 869.755n 0.0v 874.745n 0.0v 874.755n 0.0v 879.745n 0.0v 879.755n 0.0v 884.745n 0.0v 884.755n 0.0v 889.745n 0.0v 889.755n 0.0v 894.745n 0.0v 894.755n 0.0v 899.745n 0.0v 899.755n 0.0v 904.745n 0.0v 904.755n 0.0v 909.745n 0.0v 909.755n 0.0v 914.745n 0.0v 914.755n 0.0v 919.745n 0.0v 919.755n 0.0v 924.745n 0.0v 924.755n 0.0v 929.745n 0.0v 929.755n 0.0v 934.745n 0.0v 934.755n 0.0v 939.745n 0.0v 939.755n 1.1v 944.745n 1.1v 944.755n 1.1v 949.745n 1.1v 949.755n 1.1v 954.745n 1.1v 954.755n 1.1v 959.745n 1.1v 959.755n 1.1v 964.745n 1.1v 964.755n 1.1v 969.745n 1.1v 969.755n 1.1v 974.745n 1.1v 974.755n 1.1v 979.745n 1.1v 979.755n 1.1v 984.745n 1.1v 984.755n 0.0v 989.745n 0.0v 989.755n 1.1v 994.745n 1.1v 994.755n 1.1v 999.745n 1.1v 999.755n 1.1v 1004.745n 1.1v 1004.755n 1.1v 1009.745n 1.1v 1009.755n 1.1v 1014.745n 1.1v 1014.755n 1.1v 1019.745n 1.1v 1019.755n 0.0v 1024.745n 0.0v 1024.755n 0.0v )
* (time, data): [(0, 0), (5, 1), (10, 0), (15, 0), (20, 0), (25, 0), (30, 1), (35, 1), (40, 0), (45, 0), (50, 0), (55, 0), (60, 0), (65, 0), (70, 1), (75, 1), (80, 1), (85, 1), (90, 1), (95, 1), (100, 1), (105, 1), (110, 1), (115, 0), (120, 0), (125, 0), (130, 0), (135, 0), (140, 1), (145, 0), (150, 0), (155, 0), (160, 0), (165, 1), (170, 1), (175, 1), (180, 1), (185, 1), (190, 1), (195, 1), (200, 1), (205, 1), (210, 1), (215, 1), (220, 1), (225, 1), (230, 1), (235, 1), (240, 1), (245, 0), (250, 0), (255, 1), (260, 1), (265, 1), (270, 1), (275, 1), (280, 1), (285, 1), (290, 1), (295, 1), (300, 1), (305, 1), (310, 1), (315, 1), (320, 1), (325, 1), (330, 0), (335, 0), (340, 0), (345, 0), (350, 0), (355, 0), (360, 0), (365, 0), (370, 1), (375, 1), (380, 1), (385, 1), (390, 1), (395, 1), (400, 1), (405, 1), (410, 1), (415, 0), (420, 0), (425, 0), (430, 0), (435, 0), (440, 0), (445, 0), (450, 0), (455, 0), (460, 0), (465, 0), (470, 0), (475, 0), (480, 0), (485, 1), (490, 1), (495, 1), (500, 1), (505, 1), (510, 1), (515, 1), (520, 0), (525, 0), (530, 0), (535, 1), (540, 0), (545, 0), (550, 0), (555, 0), (560, 0), (565, 0), (570, 1), (575, 1), (580, 1), (585, 0), (590, 0), (595, 0), (600, 1), (605, 1), (610, 1), (615, 1), (620, 1), (625, 1), (630, 1), (635, 1), (640, 1), (645, 1), (650, 1), (655, 1), (660, 1), (665, 1), (670, 1), (675, 1), (680, 1), (685, 1), (690, 0), (695, 0), (700, 0), (705, 0), (710, 0), (715, 1), (720, 1), (725, 1), (730, 1), (735, 1), (740, 1), (745, 1), (750, 1), (755, 1), (760, 1), (765, 1), (770, 1), (775, 1), (780, 1), (785, 1), (790, 1), (795, 0), (800, 0), (805, 0), (810, 0), (815, 0), (820, 0), (825, 0), (830, 0), (835, 0), (840, 0), (845, 0), (850, 0), (855, 0), (860, 0), (865, 0), (870, 1), (875, 1), (880, 1), (885, 1), (890, 1), (895, 1), (900, 1), (905, 1), (910, 1), (915, 1), (920, 1), (925, 1), (930, 1), (935, 1), (940, 1), (945, 1), (950, 1), (955, 1), (960, 1), (965, 1), (970, 1), (975, 1), (980, 1), (985, 1), (990, 1), (995, 1), (1000, 1), (1005, 1), (1010, 1), (1015, 1), (1020, 1), (1025, 1)]
Vdin0_20  din0_20  0 PWL (0n 0.0v 4.745n 0.0v 4.755n 1.1v 9.745n 1.1v 9.755n 0.0v 14.745n 0.0v 14.755n 0.0v 19.745n 0.0v 19.755n 0.0v 24.745n 0.0v 24.755n 0.0v 29.745n 0.0v 29.755n 1.1v 34.745n 1.1v 34.755n 1.1v 39.745n 1.1v 39.755n 0.0v 44.745n 0.0v 44.755n 0.0v 49.745n 0.0v 49.755n 0.0v 54.745n 0.0v 54.755n 0.0v 59.745n 0.0v 59.755n 0.0v 64.745n 0.0v 64.755n 0.0v 69.745n 0.0v 69.755n 1.1v 74.745n 1.1v 74.755n 1.1v 79.745n 1.1v 79.755n 1.1v 84.745n 1.1v 84.755n 1.1v 89.745n 1.1v 89.755n 1.1v 94.745n 1.1v 94.755n 1.1v 99.745n 1.1v 99.755n 1.1v 104.745n 1.1v 104.755n 1.1v 109.745n 1.1v 109.755n 1.1v 114.745n 1.1v 114.755n 0.0v 119.745n 0.0v 119.755n 0.0v 124.745n 0.0v 124.755n 0.0v 129.745n 0.0v 129.755n 0.0v 134.745n 0.0v 134.755n 0.0v 139.745n 0.0v 139.755n 1.1v 144.745n 1.1v 144.755n 0.0v 149.745n 0.0v 149.755n 0.0v 154.745n 0.0v 154.755n 0.0v 159.745n 0.0v 159.755n 0.0v 164.745n 0.0v 164.755n 1.1v 169.745n 1.1v 169.755n 1.1v 174.745n 1.1v 174.755n 1.1v 179.745n 1.1v 179.755n 1.1v 184.745n 1.1v 184.755n 1.1v 189.745n 1.1v 189.755n 1.1v 194.745n 1.1v 194.755n 1.1v 199.745n 1.1v 199.755n 1.1v 204.745n 1.1v 204.755n 1.1v 209.745n 1.1v 209.755n 1.1v 214.745n 1.1v 214.755n 1.1v 219.745n 1.1v 219.755n 1.1v 224.745n 1.1v 224.755n 1.1v 229.745n 1.1v 229.755n 1.1v 234.745n 1.1v 234.755n 1.1v 239.745n 1.1v 239.755n 1.1v 244.745n 1.1v 244.755n 0.0v 249.745n 0.0v 249.755n 0.0v 254.745n 0.0v 254.755n 1.1v 259.745n 1.1v 259.755n 1.1v 264.745n 1.1v 264.755n 1.1v 269.745n 1.1v 269.755n 1.1v 274.745n 1.1v 274.755n 1.1v 279.745n 1.1v 279.755n 1.1v 284.745n 1.1v 284.755n 1.1v 289.745n 1.1v 289.755n 1.1v 294.745n 1.1v 294.755n 1.1v 299.745n 1.1v 299.755n 1.1v 304.745n 1.1v 304.755n 1.1v 309.745n 1.1v 309.755n 1.1v 314.745n 1.1v 314.755n 1.1v 319.745n 1.1v 319.755n 1.1v 324.745n 1.1v 324.755n 1.1v 329.745n 1.1v 329.755n 0.0v 334.745n 0.0v 334.755n 0.0v 339.745n 0.0v 339.755n 0.0v 344.745n 0.0v 344.755n 0.0v 349.745n 0.0v 349.755n 0.0v 354.745n 0.0v 354.755n 0.0v 359.745n 0.0v 359.755n 0.0v 364.745n 0.0v 364.755n 0.0v 369.745n 0.0v 369.755n 1.1v 374.745n 1.1v 374.755n 1.1v 379.745n 1.1v 379.755n 1.1v 384.745n 1.1v 384.755n 1.1v 389.745n 1.1v 389.755n 1.1v 394.745n 1.1v 394.755n 1.1v 399.745n 1.1v 399.755n 1.1v 404.745n 1.1v 404.755n 1.1v 409.745n 1.1v 409.755n 1.1v 414.745n 1.1v 414.755n 0.0v 419.745n 0.0v 419.755n 0.0v 424.745n 0.0v 424.755n 0.0v 429.745n 0.0v 429.755n 0.0v 434.745n 0.0v 434.755n 0.0v 439.745n 0.0v 439.755n 0.0v 444.745n 0.0v 444.755n 0.0v 449.745n 0.0v 449.755n 0.0v 454.745n 0.0v 454.755n 0.0v 459.745n 0.0v 459.755n 0.0v 464.745n 0.0v 464.755n 0.0v 469.745n 0.0v 469.755n 0.0v 474.745n 0.0v 474.755n 0.0v 479.745n 0.0v 479.755n 0.0v 484.745n 0.0v 484.755n 1.1v 489.745n 1.1v 489.755n 1.1v 494.745n 1.1v 494.755n 1.1v 499.745n 1.1v 499.755n 1.1v 504.745n 1.1v 504.755n 1.1v 509.745n 1.1v 509.755n 1.1v 514.745n 1.1v 514.755n 1.1v 519.745n 1.1v 519.755n 0.0v 524.745n 0.0v 524.755n 0.0v 529.745n 0.0v 529.755n 0.0v 534.745n 0.0v 534.755n 1.1v 539.745n 1.1v 539.755n 0.0v 544.745n 0.0v 544.755n 0.0v 549.745n 0.0v 549.755n 0.0v 554.745n 0.0v 554.755n 0.0v 559.745n 0.0v 559.755n 0.0v 564.745n 0.0v 564.755n 0.0v 569.745n 0.0v 569.755n 1.1v 574.745n 1.1v 574.755n 1.1v 579.745n 1.1v 579.755n 1.1v 584.745n 1.1v 584.755n 0.0v 589.745n 0.0v 589.755n 0.0v 594.745n 0.0v 594.755n 0.0v 599.745n 0.0v 599.755n 1.1v 604.745n 1.1v 604.755n 1.1v 609.745n 1.1v 609.755n 1.1v 614.745n 1.1v 614.755n 1.1v 619.745n 1.1v 619.755n 1.1v 624.745n 1.1v 624.755n 1.1v 629.745n 1.1v 629.755n 1.1v 634.745n 1.1v 634.755n 1.1v 639.745n 1.1v 639.755n 1.1v 644.745n 1.1v 644.755n 1.1v 649.745n 1.1v 649.755n 1.1v 654.745n 1.1v 654.755n 1.1v 659.745n 1.1v 659.755n 1.1v 664.745n 1.1v 664.755n 1.1v 669.745n 1.1v 669.755n 1.1v 674.745n 1.1v 674.755n 1.1v 679.745n 1.1v 679.755n 1.1v 684.745n 1.1v 684.755n 1.1v 689.745n 1.1v 689.755n 0.0v 694.745n 0.0v 694.755n 0.0v 699.745n 0.0v 699.755n 0.0v 704.745n 0.0v 704.755n 0.0v 709.745n 0.0v 709.755n 0.0v 714.745n 0.0v 714.755n 1.1v 719.745n 1.1v 719.755n 1.1v 724.745n 1.1v 724.755n 1.1v 729.745n 1.1v 729.755n 1.1v 734.745n 1.1v 734.755n 1.1v 739.745n 1.1v 739.755n 1.1v 744.745n 1.1v 744.755n 1.1v 749.745n 1.1v 749.755n 1.1v 754.745n 1.1v 754.755n 1.1v 759.745n 1.1v 759.755n 1.1v 764.745n 1.1v 764.755n 1.1v 769.745n 1.1v 769.755n 1.1v 774.745n 1.1v 774.755n 1.1v 779.745n 1.1v 779.755n 1.1v 784.745n 1.1v 784.755n 1.1v 789.745n 1.1v 789.755n 1.1v 794.745n 1.1v 794.755n 0.0v 799.745n 0.0v 799.755n 0.0v 804.745n 0.0v 804.755n 0.0v 809.745n 0.0v 809.755n 0.0v 814.745n 0.0v 814.755n 0.0v 819.745n 0.0v 819.755n 0.0v 824.745n 0.0v 824.755n 0.0v 829.745n 0.0v 829.755n 0.0v 834.745n 0.0v 834.755n 0.0v 839.745n 0.0v 839.755n 0.0v 844.745n 0.0v 844.755n 0.0v 849.745n 0.0v 849.755n 0.0v 854.745n 0.0v 854.755n 0.0v 859.745n 0.0v 859.755n 0.0v 864.745n 0.0v 864.755n 0.0v 869.745n 0.0v 869.755n 1.1v 874.745n 1.1v 874.755n 1.1v 879.745n 1.1v 879.755n 1.1v 884.745n 1.1v 884.755n 1.1v 889.745n 1.1v 889.755n 1.1v 894.745n 1.1v 894.755n 1.1v 899.745n 1.1v 899.755n 1.1v 904.745n 1.1v 904.755n 1.1v 909.745n 1.1v 909.755n 1.1v 914.745n 1.1v 914.755n 1.1v 919.745n 1.1v 919.755n 1.1v 924.745n 1.1v 924.755n 1.1v 929.745n 1.1v 929.755n 1.1v 934.745n 1.1v 934.755n 1.1v 939.745n 1.1v 939.755n 1.1v 944.745n 1.1v 944.755n 1.1v 949.745n 1.1v 949.755n 1.1v 954.745n 1.1v 954.755n 1.1v 959.745n 1.1v 959.755n 1.1v 964.745n 1.1v 964.755n 1.1v 969.745n 1.1v 969.755n 1.1v 974.745n 1.1v 974.755n 1.1v 979.745n 1.1v 979.755n 1.1v 984.745n 1.1v 984.755n 1.1v 989.745n 1.1v 989.755n 1.1v 994.745n 1.1v 994.755n 1.1v 999.745n 1.1v 999.755n 1.1v 1004.745n 1.1v 1004.755n 1.1v 1009.745n 1.1v 1009.755n 1.1v 1014.745n 1.1v 1014.755n 1.1v 1019.745n 1.1v 1019.755n 1.1v 1024.745n 1.1v 1024.755n 1.1v )
* (time, data): [(0, 0), (5, 1), (10, 1), (15, 0), (20, 0), (25, 0), (30, 1), (35, 0), (40, 1), (45, 1), (50, 1), (55, 1), (60, 1), (65, 1), (70, 0), (75, 0), (80, 0), (85, 0), (90, 0), (95, 0), (100, 0), (105, 0), (110, 0), (115, 0), (120, 0), (125, 0), (130, 0), (135, 1), (140, 0), (145, 0), (150, 0), (155, 0), (160, 0), (165, 0), (170, 0), (175, 0), (180, 0), (185, 0), (190, 0), (195, 0), (200, 1), (205, 1), (210, 1), (215, 1), (220, 0), (225, 0), (230, 1), (235, 1), (240, 1), (245, 0), (250, 0), (255, 1), (260, 1), (265, 1), (270, 0), (275, 0), (280, 0), (285, 0), (290, 0), (295, 0), (300, 0), (305, 1), (310, 1), (315, 1), (320, 1), (325, 1), (330, 0), (335, 0), (340, 0), (345, 0), (350, 0), (355, 0), (360, 0), (365, 0), (370, 0), (375, 1), (380, 1), (385, 0), (390, 0), (395, 0), (400, 0), (405, 0), (410, 0), (415, 1), (420, 0), (425, 0), (430, 1), (435, 1), (440, 1), (445, 1), (450, 1), (455, 1), (460, 1), (465, 1), (470, 1), (475, 1), (480, 1), (485, 1), (490, 1), (495, 1), (500, 1), (505, 1), (510, 1), (515, 1), (520, 0), (525, 0), (530, 0), (535, 0), (540, 0), (545, 0), (550, 0), (555, 1), (560, 1), (565, 1), (570, 0), (575, 0), (580, 0), (585, 1), (590, 1), (595, 1), (600, 1), (605, 1), (610, 1), (615, 1), (620, 1), (625, 1), (630, 1), (635, 1), (640, 1), (645, 1), (650, 1), (655, 0), (660, 0), (665, 0), (670, 0), (675, 0), (680, 0), (685, 0), (690, 1), (695, 1), (700, 1), (705, 1), (710, 1), (715, 0), (720, 0), (725, 1), (730, 1), (735, 1), (740, 1), (745, 1), (750, 1), (755, 1), (760, 1), (765, 1), (770, 1), (775, 1), (780, 1), (785, 1), (790, 1), (795, 1), (800, 1), (805, 1), (810, 1), (815, 1), (820, 1), (825, 1), (830, 1), (835, 1), (840, 1), (845, 1), (850, 1), (855, 1), (860, 1), (865, 1), (870, 1), (875, 1), (880, 1), (885, 1), (890, 1), (895, 1), (900, 1), (905, 1), (910, 1), (915, 1), (920, 0), (925, 0), (930, 0), (935, 0), (940, 0), (945, 0), (950, 0), (955, 0), (960, 0), (965, 0), (970, 0), (975, 0), (980, 0), (985, 0), (990, 0), (995, 0), (1000, 0), (1005, 0), (1010, 0), (1015, 0), (1020, 0), (1025, 0)]
Vdin0_21  din0_21  0 PWL (0n 0.0v 4.745n 0.0v 4.755n 1.1v 9.745n 1.1v 9.755n 1.1v 14.745n 1.1v 14.755n 0.0v 19.745n 0.0v 19.755n 0.0v 24.745n 0.0v 24.755n 0.0v 29.745n 0.0v 29.755n 1.1v 34.745n 1.1v 34.755n 0.0v 39.745n 0.0v 39.755n 1.1v 44.745n 1.1v 44.755n 1.1v 49.745n 1.1v 49.755n 1.1v 54.745n 1.1v 54.755n 1.1v 59.745n 1.1v 59.755n 1.1v 64.745n 1.1v 64.755n 1.1v 69.745n 1.1v 69.755n 0.0v 74.745n 0.0v 74.755n 0.0v 79.745n 0.0v 79.755n 0.0v 84.745n 0.0v 84.755n 0.0v 89.745n 0.0v 89.755n 0.0v 94.745n 0.0v 94.755n 0.0v 99.745n 0.0v 99.755n 0.0v 104.745n 0.0v 104.755n 0.0v 109.745n 0.0v 109.755n 0.0v 114.745n 0.0v 114.755n 0.0v 119.745n 0.0v 119.755n 0.0v 124.745n 0.0v 124.755n 0.0v 129.745n 0.0v 129.755n 0.0v 134.745n 0.0v 134.755n 1.1v 139.745n 1.1v 139.755n 0.0v 144.745n 0.0v 144.755n 0.0v 149.745n 0.0v 149.755n 0.0v 154.745n 0.0v 154.755n 0.0v 159.745n 0.0v 159.755n 0.0v 164.745n 0.0v 164.755n 0.0v 169.745n 0.0v 169.755n 0.0v 174.745n 0.0v 174.755n 0.0v 179.745n 0.0v 179.755n 0.0v 184.745n 0.0v 184.755n 0.0v 189.745n 0.0v 189.755n 0.0v 194.745n 0.0v 194.755n 0.0v 199.745n 0.0v 199.755n 1.1v 204.745n 1.1v 204.755n 1.1v 209.745n 1.1v 209.755n 1.1v 214.745n 1.1v 214.755n 1.1v 219.745n 1.1v 219.755n 0.0v 224.745n 0.0v 224.755n 0.0v 229.745n 0.0v 229.755n 1.1v 234.745n 1.1v 234.755n 1.1v 239.745n 1.1v 239.755n 1.1v 244.745n 1.1v 244.755n 0.0v 249.745n 0.0v 249.755n 0.0v 254.745n 0.0v 254.755n 1.1v 259.745n 1.1v 259.755n 1.1v 264.745n 1.1v 264.755n 1.1v 269.745n 1.1v 269.755n 0.0v 274.745n 0.0v 274.755n 0.0v 279.745n 0.0v 279.755n 0.0v 284.745n 0.0v 284.755n 0.0v 289.745n 0.0v 289.755n 0.0v 294.745n 0.0v 294.755n 0.0v 299.745n 0.0v 299.755n 0.0v 304.745n 0.0v 304.755n 1.1v 309.745n 1.1v 309.755n 1.1v 314.745n 1.1v 314.755n 1.1v 319.745n 1.1v 319.755n 1.1v 324.745n 1.1v 324.755n 1.1v 329.745n 1.1v 329.755n 0.0v 334.745n 0.0v 334.755n 0.0v 339.745n 0.0v 339.755n 0.0v 344.745n 0.0v 344.755n 0.0v 349.745n 0.0v 349.755n 0.0v 354.745n 0.0v 354.755n 0.0v 359.745n 0.0v 359.755n 0.0v 364.745n 0.0v 364.755n 0.0v 369.745n 0.0v 369.755n 0.0v 374.745n 0.0v 374.755n 1.1v 379.745n 1.1v 379.755n 1.1v 384.745n 1.1v 384.755n 0.0v 389.745n 0.0v 389.755n 0.0v 394.745n 0.0v 394.755n 0.0v 399.745n 0.0v 399.755n 0.0v 404.745n 0.0v 404.755n 0.0v 409.745n 0.0v 409.755n 0.0v 414.745n 0.0v 414.755n 1.1v 419.745n 1.1v 419.755n 0.0v 424.745n 0.0v 424.755n 0.0v 429.745n 0.0v 429.755n 1.1v 434.745n 1.1v 434.755n 1.1v 439.745n 1.1v 439.755n 1.1v 444.745n 1.1v 444.755n 1.1v 449.745n 1.1v 449.755n 1.1v 454.745n 1.1v 454.755n 1.1v 459.745n 1.1v 459.755n 1.1v 464.745n 1.1v 464.755n 1.1v 469.745n 1.1v 469.755n 1.1v 474.745n 1.1v 474.755n 1.1v 479.745n 1.1v 479.755n 1.1v 484.745n 1.1v 484.755n 1.1v 489.745n 1.1v 489.755n 1.1v 494.745n 1.1v 494.755n 1.1v 499.745n 1.1v 499.755n 1.1v 504.745n 1.1v 504.755n 1.1v 509.745n 1.1v 509.755n 1.1v 514.745n 1.1v 514.755n 1.1v 519.745n 1.1v 519.755n 0.0v 524.745n 0.0v 524.755n 0.0v 529.745n 0.0v 529.755n 0.0v 534.745n 0.0v 534.755n 0.0v 539.745n 0.0v 539.755n 0.0v 544.745n 0.0v 544.755n 0.0v 549.745n 0.0v 549.755n 0.0v 554.745n 0.0v 554.755n 1.1v 559.745n 1.1v 559.755n 1.1v 564.745n 1.1v 564.755n 1.1v 569.745n 1.1v 569.755n 0.0v 574.745n 0.0v 574.755n 0.0v 579.745n 0.0v 579.755n 0.0v 584.745n 0.0v 584.755n 1.1v 589.745n 1.1v 589.755n 1.1v 594.745n 1.1v 594.755n 1.1v 599.745n 1.1v 599.755n 1.1v 604.745n 1.1v 604.755n 1.1v 609.745n 1.1v 609.755n 1.1v 614.745n 1.1v 614.755n 1.1v 619.745n 1.1v 619.755n 1.1v 624.745n 1.1v 624.755n 1.1v 629.745n 1.1v 629.755n 1.1v 634.745n 1.1v 634.755n 1.1v 639.745n 1.1v 639.755n 1.1v 644.745n 1.1v 644.755n 1.1v 649.745n 1.1v 649.755n 1.1v 654.745n 1.1v 654.755n 0.0v 659.745n 0.0v 659.755n 0.0v 664.745n 0.0v 664.755n 0.0v 669.745n 0.0v 669.755n 0.0v 674.745n 0.0v 674.755n 0.0v 679.745n 0.0v 679.755n 0.0v 684.745n 0.0v 684.755n 0.0v 689.745n 0.0v 689.755n 1.1v 694.745n 1.1v 694.755n 1.1v 699.745n 1.1v 699.755n 1.1v 704.745n 1.1v 704.755n 1.1v 709.745n 1.1v 709.755n 1.1v 714.745n 1.1v 714.755n 0.0v 719.745n 0.0v 719.755n 0.0v 724.745n 0.0v 724.755n 1.1v 729.745n 1.1v 729.755n 1.1v 734.745n 1.1v 734.755n 1.1v 739.745n 1.1v 739.755n 1.1v 744.745n 1.1v 744.755n 1.1v 749.745n 1.1v 749.755n 1.1v 754.745n 1.1v 754.755n 1.1v 759.745n 1.1v 759.755n 1.1v 764.745n 1.1v 764.755n 1.1v 769.745n 1.1v 769.755n 1.1v 774.745n 1.1v 774.755n 1.1v 779.745n 1.1v 779.755n 1.1v 784.745n 1.1v 784.755n 1.1v 789.745n 1.1v 789.755n 1.1v 794.745n 1.1v 794.755n 1.1v 799.745n 1.1v 799.755n 1.1v 804.745n 1.1v 804.755n 1.1v 809.745n 1.1v 809.755n 1.1v 814.745n 1.1v 814.755n 1.1v 819.745n 1.1v 819.755n 1.1v 824.745n 1.1v 824.755n 1.1v 829.745n 1.1v 829.755n 1.1v 834.745n 1.1v 834.755n 1.1v 839.745n 1.1v 839.755n 1.1v 844.745n 1.1v 844.755n 1.1v 849.745n 1.1v 849.755n 1.1v 854.745n 1.1v 854.755n 1.1v 859.745n 1.1v 859.755n 1.1v 864.745n 1.1v 864.755n 1.1v 869.745n 1.1v 869.755n 1.1v 874.745n 1.1v 874.755n 1.1v 879.745n 1.1v 879.755n 1.1v 884.745n 1.1v 884.755n 1.1v 889.745n 1.1v 889.755n 1.1v 894.745n 1.1v 894.755n 1.1v 899.745n 1.1v 899.755n 1.1v 904.745n 1.1v 904.755n 1.1v 909.745n 1.1v 909.755n 1.1v 914.745n 1.1v 914.755n 1.1v 919.745n 1.1v 919.755n 0.0v 924.745n 0.0v 924.755n 0.0v 929.745n 0.0v 929.755n 0.0v 934.745n 0.0v 934.755n 0.0v 939.745n 0.0v 939.755n 0.0v 944.745n 0.0v 944.755n 0.0v 949.745n 0.0v 949.755n 0.0v 954.745n 0.0v 954.755n 0.0v 959.745n 0.0v 959.755n 0.0v 964.745n 0.0v 964.755n 0.0v 969.745n 0.0v 969.755n 0.0v 974.745n 0.0v 974.755n 0.0v 979.745n 0.0v 979.755n 0.0v 984.745n 0.0v 984.755n 0.0v 989.745n 0.0v 989.755n 0.0v 994.745n 0.0v 994.755n 0.0v 999.745n 0.0v 999.755n 0.0v 1004.745n 0.0v 1004.755n 0.0v 1009.745n 0.0v 1009.755n 0.0v 1014.745n 0.0v 1014.755n 0.0v 1019.745n 0.0v 1019.755n 0.0v 1024.745n 0.0v 1024.755n 0.0v )
* (time, data): [(0, 0), (5, 1), (10, 1), (15, 0), (20, 0), (25, 0), (30, 0), (35, 1), (40, 0), (45, 0), (50, 0), (55, 0), (60, 1), (65, 1), (70, 1), (75, 1), (80, 1), (85, 1), (90, 1), (95, 1), (100, 0), (105, 0), (110, 0), (115, 0), (120, 0), (125, 1), (130, 1), (135, 0), (140, 0), (145, 1), (150, 1), (155, 1), (160, 1), (165, 1), (170, 1), (175, 1), (180, 1), (185, 1), (190, 1), (195, 1), (200, 0), (205, 0), (210, 0), (215, 0), (220, 1), (225, 1), (230, 0), (235, 0), (240, 0), (245, 0), (250, 0), (255, 0), (260, 0), (265, 0), (270, 0), (275, 0), (280, 0), (285, 1), (290, 1), (295, 1), (300, 1), (305, 1), (310, 1), (315, 1), (320, 1), (325, 0), (330, 0), (335, 0), (340, 0), (345, 0), (350, 0), (355, 0), (360, 0), (365, 0), (370, 0), (375, 0), (380, 0), (385, 1), (390, 1), (395, 1), (400, 1), (405, 1), (410, 1), (415, 1), (420, 0), (425, 0), (430, 1), (435, 1), (440, 1), (445, 1), (450, 1), (455, 1), (460, 1), (465, 1), (470, 1), (475, 1), (480, 1), (485, 1), (490, 1), (495, 1), (500, 1), (505, 1), (510, 1), (515, 1), (520, 0), (525, 0), (530, 0), (535, 1), (540, 0), (545, 0), (550, 0), (555, 1), (560, 1), (565, 1), (570, 0), (575, 0), (580, 0), (585, 1), (590, 1), (595, 1), (600, 0), (605, 0), (610, 0), (615, 0), (620, 0), (625, 0), (630, 0), (635, 0), (640, 0), (645, 0), (650, 0), (655, 1), (660, 1), (665, 1), (670, 1), (675, 1), (680, 1), (685, 1), (690, 1), (695, 1), (700, 1), (705, 1), (710, 1), (715, 0), (720, 0), (725, 0), (730, 0), (735, 0), (740, 0), (745, 0), (750, 0), (755, 0), (760, 0), (765, 0), (770, 0), (775, 0), (780, 0), (785, 0), (790, 0), (795, 1), (800, 1), (805, 1), (810, 1), (815, 1), (820, 1), (825, 1), (830, 1), (835, 1), (840, 0), (845, 0), (850, 0), (855, 0), (860, 0), (865, 0), (870, 1), (875, 1), (880, 1), (885, 1), (890, 1), (895, 1), (900, 1), (905, 1), (910, 1), (915, 1), (920, 1), (925, 1), (930, 1), (935, 1), (940, 0), (945, 0), (950, 0), (955, 0), (960, 0), (965, 0), (970, 0), (975, 0), (980, 0), (985, 1), (990, 0), (995, 0), (1000, 0), (1005, 0), (1010, 0), (1015, 0), (1020, 1), (1025, 1)]
Vdin0_22  din0_22  0 PWL (0n 0.0v 4.745n 0.0v 4.755n 1.1v 9.745n 1.1v 9.755n 1.1v 14.745n 1.1v 14.755n 0.0v 19.745n 0.0v 19.755n 0.0v 24.745n 0.0v 24.755n 0.0v 29.745n 0.0v 29.755n 0.0v 34.745n 0.0v 34.755n 1.1v 39.745n 1.1v 39.755n 0.0v 44.745n 0.0v 44.755n 0.0v 49.745n 0.0v 49.755n 0.0v 54.745n 0.0v 54.755n 0.0v 59.745n 0.0v 59.755n 1.1v 64.745n 1.1v 64.755n 1.1v 69.745n 1.1v 69.755n 1.1v 74.745n 1.1v 74.755n 1.1v 79.745n 1.1v 79.755n 1.1v 84.745n 1.1v 84.755n 1.1v 89.745n 1.1v 89.755n 1.1v 94.745n 1.1v 94.755n 1.1v 99.745n 1.1v 99.755n 0.0v 104.745n 0.0v 104.755n 0.0v 109.745n 0.0v 109.755n 0.0v 114.745n 0.0v 114.755n 0.0v 119.745n 0.0v 119.755n 0.0v 124.745n 0.0v 124.755n 1.1v 129.745n 1.1v 129.755n 1.1v 134.745n 1.1v 134.755n 0.0v 139.745n 0.0v 139.755n 0.0v 144.745n 0.0v 144.755n 1.1v 149.745n 1.1v 149.755n 1.1v 154.745n 1.1v 154.755n 1.1v 159.745n 1.1v 159.755n 1.1v 164.745n 1.1v 164.755n 1.1v 169.745n 1.1v 169.755n 1.1v 174.745n 1.1v 174.755n 1.1v 179.745n 1.1v 179.755n 1.1v 184.745n 1.1v 184.755n 1.1v 189.745n 1.1v 189.755n 1.1v 194.745n 1.1v 194.755n 1.1v 199.745n 1.1v 199.755n 0.0v 204.745n 0.0v 204.755n 0.0v 209.745n 0.0v 209.755n 0.0v 214.745n 0.0v 214.755n 0.0v 219.745n 0.0v 219.755n 1.1v 224.745n 1.1v 224.755n 1.1v 229.745n 1.1v 229.755n 0.0v 234.745n 0.0v 234.755n 0.0v 239.745n 0.0v 239.755n 0.0v 244.745n 0.0v 244.755n 0.0v 249.745n 0.0v 249.755n 0.0v 254.745n 0.0v 254.755n 0.0v 259.745n 0.0v 259.755n 0.0v 264.745n 0.0v 264.755n 0.0v 269.745n 0.0v 269.755n 0.0v 274.745n 0.0v 274.755n 0.0v 279.745n 0.0v 279.755n 0.0v 284.745n 0.0v 284.755n 1.1v 289.745n 1.1v 289.755n 1.1v 294.745n 1.1v 294.755n 1.1v 299.745n 1.1v 299.755n 1.1v 304.745n 1.1v 304.755n 1.1v 309.745n 1.1v 309.755n 1.1v 314.745n 1.1v 314.755n 1.1v 319.745n 1.1v 319.755n 1.1v 324.745n 1.1v 324.755n 0.0v 329.745n 0.0v 329.755n 0.0v 334.745n 0.0v 334.755n 0.0v 339.745n 0.0v 339.755n 0.0v 344.745n 0.0v 344.755n 0.0v 349.745n 0.0v 349.755n 0.0v 354.745n 0.0v 354.755n 0.0v 359.745n 0.0v 359.755n 0.0v 364.745n 0.0v 364.755n 0.0v 369.745n 0.0v 369.755n 0.0v 374.745n 0.0v 374.755n 0.0v 379.745n 0.0v 379.755n 0.0v 384.745n 0.0v 384.755n 1.1v 389.745n 1.1v 389.755n 1.1v 394.745n 1.1v 394.755n 1.1v 399.745n 1.1v 399.755n 1.1v 404.745n 1.1v 404.755n 1.1v 409.745n 1.1v 409.755n 1.1v 414.745n 1.1v 414.755n 1.1v 419.745n 1.1v 419.755n 0.0v 424.745n 0.0v 424.755n 0.0v 429.745n 0.0v 429.755n 1.1v 434.745n 1.1v 434.755n 1.1v 439.745n 1.1v 439.755n 1.1v 444.745n 1.1v 444.755n 1.1v 449.745n 1.1v 449.755n 1.1v 454.745n 1.1v 454.755n 1.1v 459.745n 1.1v 459.755n 1.1v 464.745n 1.1v 464.755n 1.1v 469.745n 1.1v 469.755n 1.1v 474.745n 1.1v 474.755n 1.1v 479.745n 1.1v 479.755n 1.1v 484.745n 1.1v 484.755n 1.1v 489.745n 1.1v 489.755n 1.1v 494.745n 1.1v 494.755n 1.1v 499.745n 1.1v 499.755n 1.1v 504.745n 1.1v 504.755n 1.1v 509.745n 1.1v 509.755n 1.1v 514.745n 1.1v 514.755n 1.1v 519.745n 1.1v 519.755n 0.0v 524.745n 0.0v 524.755n 0.0v 529.745n 0.0v 529.755n 0.0v 534.745n 0.0v 534.755n 1.1v 539.745n 1.1v 539.755n 0.0v 544.745n 0.0v 544.755n 0.0v 549.745n 0.0v 549.755n 0.0v 554.745n 0.0v 554.755n 1.1v 559.745n 1.1v 559.755n 1.1v 564.745n 1.1v 564.755n 1.1v 569.745n 1.1v 569.755n 0.0v 574.745n 0.0v 574.755n 0.0v 579.745n 0.0v 579.755n 0.0v 584.745n 0.0v 584.755n 1.1v 589.745n 1.1v 589.755n 1.1v 594.745n 1.1v 594.755n 1.1v 599.745n 1.1v 599.755n 0.0v 604.745n 0.0v 604.755n 0.0v 609.745n 0.0v 609.755n 0.0v 614.745n 0.0v 614.755n 0.0v 619.745n 0.0v 619.755n 0.0v 624.745n 0.0v 624.755n 0.0v 629.745n 0.0v 629.755n 0.0v 634.745n 0.0v 634.755n 0.0v 639.745n 0.0v 639.755n 0.0v 644.745n 0.0v 644.755n 0.0v 649.745n 0.0v 649.755n 0.0v 654.745n 0.0v 654.755n 1.1v 659.745n 1.1v 659.755n 1.1v 664.745n 1.1v 664.755n 1.1v 669.745n 1.1v 669.755n 1.1v 674.745n 1.1v 674.755n 1.1v 679.745n 1.1v 679.755n 1.1v 684.745n 1.1v 684.755n 1.1v 689.745n 1.1v 689.755n 1.1v 694.745n 1.1v 694.755n 1.1v 699.745n 1.1v 699.755n 1.1v 704.745n 1.1v 704.755n 1.1v 709.745n 1.1v 709.755n 1.1v 714.745n 1.1v 714.755n 0.0v 719.745n 0.0v 719.755n 0.0v 724.745n 0.0v 724.755n 0.0v 729.745n 0.0v 729.755n 0.0v 734.745n 0.0v 734.755n 0.0v 739.745n 0.0v 739.755n 0.0v 744.745n 0.0v 744.755n 0.0v 749.745n 0.0v 749.755n 0.0v 754.745n 0.0v 754.755n 0.0v 759.745n 0.0v 759.755n 0.0v 764.745n 0.0v 764.755n 0.0v 769.745n 0.0v 769.755n 0.0v 774.745n 0.0v 774.755n 0.0v 779.745n 0.0v 779.755n 0.0v 784.745n 0.0v 784.755n 0.0v 789.745n 0.0v 789.755n 0.0v 794.745n 0.0v 794.755n 1.1v 799.745n 1.1v 799.755n 1.1v 804.745n 1.1v 804.755n 1.1v 809.745n 1.1v 809.755n 1.1v 814.745n 1.1v 814.755n 1.1v 819.745n 1.1v 819.755n 1.1v 824.745n 1.1v 824.755n 1.1v 829.745n 1.1v 829.755n 1.1v 834.745n 1.1v 834.755n 1.1v 839.745n 1.1v 839.755n 0.0v 844.745n 0.0v 844.755n 0.0v 849.745n 0.0v 849.755n 0.0v 854.745n 0.0v 854.755n 0.0v 859.745n 0.0v 859.755n 0.0v 864.745n 0.0v 864.755n 0.0v 869.745n 0.0v 869.755n 1.1v 874.745n 1.1v 874.755n 1.1v 879.745n 1.1v 879.755n 1.1v 884.745n 1.1v 884.755n 1.1v 889.745n 1.1v 889.755n 1.1v 894.745n 1.1v 894.755n 1.1v 899.745n 1.1v 899.755n 1.1v 904.745n 1.1v 904.755n 1.1v 909.745n 1.1v 909.755n 1.1v 914.745n 1.1v 914.755n 1.1v 919.745n 1.1v 919.755n 1.1v 924.745n 1.1v 924.755n 1.1v 929.745n 1.1v 929.755n 1.1v 934.745n 1.1v 934.755n 1.1v 939.745n 1.1v 939.755n 0.0v 944.745n 0.0v 944.755n 0.0v 949.745n 0.0v 949.755n 0.0v 954.745n 0.0v 954.755n 0.0v 959.745n 0.0v 959.755n 0.0v 964.745n 0.0v 964.755n 0.0v 969.745n 0.0v 969.755n 0.0v 974.745n 0.0v 974.755n 0.0v 979.745n 0.0v 979.755n 0.0v 984.745n 0.0v 984.755n 1.1v 989.745n 1.1v 989.755n 0.0v 994.745n 0.0v 994.755n 0.0v 999.745n 0.0v 999.755n 0.0v 1004.745n 0.0v 1004.755n 0.0v 1009.745n 0.0v 1009.755n 0.0v 1014.745n 0.0v 1014.755n 0.0v 1019.745n 0.0v 1019.755n 1.1v 1024.745n 1.1v 1024.755n 1.1v )
* (time, data): [(0, 0), (5, 0), (10, 0), (15, 0), (20, 0), (25, 0), (30, 0), (35, 1), (40, 1), (45, 1), (50, 1), (55, 1), (60, 1), (65, 1), (70, 1), (75, 1), (80, 1), (85, 1), (90, 1), (95, 1), (100, 0), (105, 0), (110, 0), (115, 1), (120, 1), (125, 1), (130, 1), (135, 1), (140, 0), (145, 1), (150, 1), (155, 1), (160, 1), (165, 1), (170, 1), (175, 1), (180, 1), (185, 1), (190, 1), (195, 1), (200, 1), (205, 1), (210, 1), (215, 1), (220, 0), (225, 0), (230, 0), (235, 0), (240, 0), (245, 0), (250, 0), (255, 1), (260, 1), (265, 1), (270, 1), (275, 1), (280, 1), (285, 1), (290, 1), (295, 1), (300, 1), (305, 0), (310, 0), (315, 0), (320, 0), (325, 0), (330, 0), (335, 0), (340, 0), (345, 1), (350, 1), (355, 1), (360, 1), (365, 1), (370, 0), (375, 1), (380, 1), (385, 0), (390, 0), (395, 0), (400, 0), (405, 0), (410, 0), (415, 0), (420, 1), (425, 1), (430, 0), (435, 0), (440, 0), (445, 0), (450, 0), (455, 0), (460, 0), (465, 0), (470, 0), (475, 0), (480, 1), (485, 1), (490, 1), (495, 0), (500, 0), (505, 0), (510, 0), (515, 0), (520, 0), (525, 0), (530, 0), (535, 1), (540, 1), (545, 1), (550, 1), (555, 1), (560, 1), (565, 1), (570, 0), (575, 0), (580, 0), (585, 1), (590, 1), (595, 1), (600, 0), (605, 0), (610, 0), (615, 0), (620, 0), (625, 0), (630, 0), (635, 0), (640, 0), (645, 0), (650, 1), (655, 1), (660, 1), (665, 1), (670, 1), (675, 1), (680, 1), (685, 1), (690, 0), (695, 0), (700, 0), (705, 0), (710, 0), (715, 1), (720, 1), (725, 0), (730, 0), (735, 0), (740, 0), (745, 0), (750, 0), (755, 0), (760, 0), (765, 0), (770, 0), (775, 0), (780, 0), (785, 0), (790, 0), (795, 0), (800, 0), (805, 0), (810, 0), (815, 0), (820, 0), (825, 0), (830, 0), (835, 0), (840, 0), (845, 0), (850, 0), (855, 0), (860, 0), (865, 0), (870, 1), (875, 1), (880, 1), (885, 1), (890, 1), (895, 0), (900, 0), (905, 0), (910, 0), (915, 0), (920, 0), (925, 0), (930, 0), (935, 0), (940, 1), (945, 1), (950, 1), (955, 1), (960, 1), (965, 1), (970, 1), (975, 1), (980, 1), (985, 1), (990, 0), (995, 0), (1000, 0), (1005, 0), (1010, 0), (1015, 1), (1020, 0), (1025, 0)]
Vdin0_23  din0_23  0 PWL (0n 0.0v 4.745n 0.0v 4.755n 0.0v 9.745n 0.0v 9.755n 0.0v 14.745n 0.0v 14.755n 0.0v 19.745n 0.0v 19.755n 0.0v 24.745n 0.0v 24.755n 0.0v 29.745n 0.0v 29.755n 0.0v 34.745n 0.0v 34.755n 1.1v 39.745n 1.1v 39.755n 1.1v 44.745n 1.1v 44.755n 1.1v 49.745n 1.1v 49.755n 1.1v 54.745n 1.1v 54.755n 1.1v 59.745n 1.1v 59.755n 1.1v 64.745n 1.1v 64.755n 1.1v 69.745n 1.1v 69.755n 1.1v 74.745n 1.1v 74.755n 1.1v 79.745n 1.1v 79.755n 1.1v 84.745n 1.1v 84.755n 1.1v 89.745n 1.1v 89.755n 1.1v 94.745n 1.1v 94.755n 1.1v 99.745n 1.1v 99.755n 0.0v 104.745n 0.0v 104.755n 0.0v 109.745n 0.0v 109.755n 0.0v 114.745n 0.0v 114.755n 1.1v 119.745n 1.1v 119.755n 1.1v 124.745n 1.1v 124.755n 1.1v 129.745n 1.1v 129.755n 1.1v 134.745n 1.1v 134.755n 1.1v 139.745n 1.1v 139.755n 0.0v 144.745n 0.0v 144.755n 1.1v 149.745n 1.1v 149.755n 1.1v 154.745n 1.1v 154.755n 1.1v 159.745n 1.1v 159.755n 1.1v 164.745n 1.1v 164.755n 1.1v 169.745n 1.1v 169.755n 1.1v 174.745n 1.1v 174.755n 1.1v 179.745n 1.1v 179.755n 1.1v 184.745n 1.1v 184.755n 1.1v 189.745n 1.1v 189.755n 1.1v 194.745n 1.1v 194.755n 1.1v 199.745n 1.1v 199.755n 1.1v 204.745n 1.1v 204.755n 1.1v 209.745n 1.1v 209.755n 1.1v 214.745n 1.1v 214.755n 1.1v 219.745n 1.1v 219.755n 0.0v 224.745n 0.0v 224.755n 0.0v 229.745n 0.0v 229.755n 0.0v 234.745n 0.0v 234.755n 0.0v 239.745n 0.0v 239.755n 0.0v 244.745n 0.0v 244.755n 0.0v 249.745n 0.0v 249.755n 0.0v 254.745n 0.0v 254.755n 1.1v 259.745n 1.1v 259.755n 1.1v 264.745n 1.1v 264.755n 1.1v 269.745n 1.1v 269.755n 1.1v 274.745n 1.1v 274.755n 1.1v 279.745n 1.1v 279.755n 1.1v 284.745n 1.1v 284.755n 1.1v 289.745n 1.1v 289.755n 1.1v 294.745n 1.1v 294.755n 1.1v 299.745n 1.1v 299.755n 1.1v 304.745n 1.1v 304.755n 0.0v 309.745n 0.0v 309.755n 0.0v 314.745n 0.0v 314.755n 0.0v 319.745n 0.0v 319.755n 0.0v 324.745n 0.0v 324.755n 0.0v 329.745n 0.0v 329.755n 0.0v 334.745n 0.0v 334.755n 0.0v 339.745n 0.0v 339.755n 0.0v 344.745n 0.0v 344.755n 1.1v 349.745n 1.1v 349.755n 1.1v 354.745n 1.1v 354.755n 1.1v 359.745n 1.1v 359.755n 1.1v 364.745n 1.1v 364.755n 1.1v 369.745n 1.1v 369.755n 0.0v 374.745n 0.0v 374.755n 1.1v 379.745n 1.1v 379.755n 1.1v 384.745n 1.1v 384.755n 0.0v 389.745n 0.0v 389.755n 0.0v 394.745n 0.0v 394.755n 0.0v 399.745n 0.0v 399.755n 0.0v 404.745n 0.0v 404.755n 0.0v 409.745n 0.0v 409.755n 0.0v 414.745n 0.0v 414.755n 0.0v 419.745n 0.0v 419.755n 1.1v 424.745n 1.1v 424.755n 1.1v 429.745n 1.1v 429.755n 0.0v 434.745n 0.0v 434.755n 0.0v 439.745n 0.0v 439.755n 0.0v 444.745n 0.0v 444.755n 0.0v 449.745n 0.0v 449.755n 0.0v 454.745n 0.0v 454.755n 0.0v 459.745n 0.0v 459.755n 0.0v 464.745n 0.0v 464.755n 0.0v 469.745n 0.0v 469.755n 0.0v 474.745n 0.0v 474.755n 0.0v 479.745n 0.0v 479.755n 1.1v 484.745n 1.1v 484.755n 1.1v 489.745n 1.1v 489.755n 1.1v 494.745n 1.1v 494.755n 0.0v 499.745n 0.0v 499.755n 0.0v 504.745n 0.0v 504.755n 0.0v 509.745n 0.0v 509.755n 0.0v 514.745n 0.0v 514.755n 0.0v 519.745n 0.0v 519.755n 0.0v 524.745n 0.0v 524.755n 0.0v 529.745n 0.0v 529.755n 0.0v 534.745n 0.0v 534.755n 1.1v 539.745n 1.1v 539.755n 1.1v 544.745n 1.1v 544.755n 1.1v 549.745n 1.1v 549.755n 1.1v 554.745n 1.1v 554.755n 1.1v 559.745n 1.1v 559.755n 1.1v 564.745n 1.1v 564.755n 1.1v 569.745n 1.1v 569.755n 0.0v 574.745n 0.0v 574.755n 0.0v 579.745n 0.0v 579.755n 0.0v 584.745n 0.0v 584.755n 1.1v 589.745n 1.1v 589.755n 1.1v 594.745n 1.1v 594.755n 1.1v 599.745n 1.1v 599.755n 0.0v 604.745n 0.0v 604.755n 0.0v 609.745n 0.0v 609.755n 0.0v 614.745n 0.0v 614.755n 0.0v 619.745n 0.0v 619.755n 0.0v 624.745n 0.0v 624.755n 0.0v 629.745n 0.0v 629.755n 0.0v 634.745n 0.0v 634.755n 0.0v 639.745n 0.0v 639.755n 0.0v 644.745n 0.0v 644.755n 0.0v 649.745n 0.0v 649.755n 1.1v 654.745n 1.1v 654.755n 1.1v 659.745n 1.1v 659.755n 1.1v 664.745n 1.1v 664.755n 1.1v 669.745n 1.1v 669.755n 1.1v 674.745n 1.1v 674.755n 1.1v 679.745n 1.1v 679.755n 1.1v 684.745n 1.1v 684.755n 1.1v 689.745n 1.1v 689.755n 0.0v 694.745n 0.0v 694.755n 0.0v 699.745n 0.0v 699.755n 0.0v 704.745n 0.0v 704.755n 0.0v 709.745n 0.0v 709.755n 0.0v 714.745n 0.0v 714.755n 1.1v 719.745n 1.1v 719.755n 1.1v 724.745n 1.1v 724.755n 0.0v 729.745n 0.0v 729.755n 0.0v 734.745n 0.0v 734.755n 0.0v 739.745n 0.0v 739.755n 0.0v 744.745n 0.0v 744.755n 0.0v 749.745n 0.0v 749.755n 0.0v 754.745n 0.0v 754.755n 0.0v 759.745n 0.0v 759.755n 0.0v 764.745n 0.0v 764.755n 0.0v 769.745n 0.0v 769.755n 0.0v 774.745n 0.0v 774.755n 0.0v 779.745n 0.0v 779.755n 0.0v 784.745n 0.0v 784.755n 0.0v 789.745n 0.0v 789.755n 0.0v 794.745n 0.0v 794.755n 0.0v 799.745n 0.0v 799.755n 0.0v 804.745n 0.0v 804.755n 0.0v 809.745n 0.0v 809.755n 0.0v 814.745n 0.0v 814.755n 0.0v 819.745n 0.0v 819.755n 0.0v 824.745n 0.0v 824.755n 0.0v 829.745n 0.0v 829.755n 0.0v 834.745n 0.0v 834.755n 0.0v 839.745n 0.0v 839.755n 0.0v 844.745n 0.0v 844.755n 0.0v 849.745n 0.0v 849.755n 0.0v 854.745n 0.0v 854.755n 0.0v 859.745n 0.0v 859.755n 0.0v 864.745n 0.0v 864.755n 0.0v 869.745n 0.0v 869.755n 1.1v 874.745n 1.1v 874.755n 1.1v 879.745n 1.1v 879.755n 1.1v 884.745n 1.1v 884.755n 1.1v 889.745n 1.1v 889.755n 1.1v 894.745n 1.1v 894.755n 0.0v 899.745n 0.0v 899.755n 0.0v 904.745n 0.0v 904.755n 0.0v 909.745n 0.0v 909.755n 0.0v 914.745n 0.0v 914.755n 0.0v 919.745n 0.0v 919.755n 0.0v 924.745n 0.0v 924.755n 0.0v 929.745n 0.0v 929.755n 0.0v 934.745n 0.0v 934.755n 0.0v 939.745n 0.0v 939.755n 1.1v 944.745n 1.1v 944.755n 1.1v 949.745n 1.1v 949.755n 1.1v 954.745n 1.1v 954.755n 1.1v 959.745n 1.1v 959.755n 1.1v 964.745n 1.1v 964.755n 1.1v 969.745n 1.1v 969.755n 1.1v 974.745n 1.1v 974.755n 1.1v 979.745n 1.1v 979.755n 1.1v 984.745n 1.1v 984.755n 1.1v 989.745n 1.1v 989.755n 0.0v 994.745n 0.0v 994.755n 0.0v 999.745n 0.0v 999.755n 0.0v 1004.745n 0.0v 1004.755n 0.0v 1009.745n 0.0v 1009.755n 0.0v 1014.745n 0.0v 1014.755n 1.1v 1019.745n 1.1v 1019.755n 0.0v 1024.745n 0.0v 1024.755n 0.0v )
* (time, data): [(0, 0), (5, 0), (10, 0), (15, 1), (20, 1), (25, 1), (30, 0), (35, 1), (40, 0), (45, 0), (50, 0), (55, 0), (60, 1), (65, 1), (70, 0), (75, 0), (80, 0), (85, 0), (90, 0), (95, 0), (100, 0), (105, 0), (110, 0), (115, 1), (120, 1), (125, 1), (130, 1), (135, 0), (140, 1), (145, 1), (150, 1), (155, 1), (160, 1), (165, 0), (170, 0), (175, 0), (180, 0), (185, 0), (190, 0), (195, 0), (200, 1), (205, 1), (210, 1), (215, 1), (220, 0), (225, 0), (230, 1), (235, 1), (240, 1), (245, 0), (250, 0), (255, 0), (260, 0), (265, 0), (270, 1), (275, 1), (280, 1), (285, 1), (290, 1), (295, 1), (300, 1), (305, 1), (310, 1), (315, 1), (320, 1), (325, 0), (330, 1), (335, 1), (340, 1), (345, 1), (350, 1), (355, 1), (360, 1), (365, 1), (370, 1), (375, 0), (380, 0), (385, 0), (390, 0), (395, 0), (400, 0), (405, 0), (410, 0), (415, 1), (420, 1), (425, 1), (430, 1), (435, 1), (440, 1), (445, 1), (450, 1), (455, 1), (460, 1), (465, 1), (470, 1), (475, 1), (480, 0), (485, 1), (490, 1), (495, 0), (500, 0), (505, 0), (510, 0), (515, 0), (520, 0), (525, 0), (530, 0), (535, 1), (540, 0), (545, 0), (550, 0), (555, 0), (560, 0), (565, 0), (570, 1), (575, 1), (580, 1), (585, 0), (590, 0), (595, 0), (600, 0), (605, 0), (610, 0), (615, 0), (620, 1), (625, 1), (630, 1), (635, 1), (640, 1), (645, 1), (650, 0), (655, 0), (660, 0), (665, 0), (670, 0), (675, 0), (680, 0), (685, 0), (690, 1), (695, 1), (700, 1), (705, 1), (710, 1), (715, 0), (720, 0), (725, 1), (730, 1), (735, 1), (740, 1), (745, 1), (750, 1), (755, 1), (760, 1), (765, 1), (770, 1), (775, 1), (780, 1), (785, 1), (790, 1), (795, 1), (800, 1), (805, 1), (810, 1), (815, 1), (820, 1), (825, 1), (830, 1), (835, 1), (840, 0), (845, 0), (850, 0), (855, 0), (860, 0), (865, 0), (870, 0), (875, 0), (880, 0), (885, 0), (890, 0), (895, 1), (900, 1), (905, 1), (910, 1), (915, 1), (920, 1), (925, 1), (930, 1), (935, 1), (940, 0), (945, 0), (950, 0), (955, 0), (960, 0), (965, 0), (970, 0), (975, 0), (980, 0), (985, 0), (990, 0), (995, 0), (1000, 0), (1005, 0), (1010, 0), (1015, 1), (1020, 0), (1025, 0)]
Vdin0_24  din0_24  0 PWL (0n 0.0v 4.745n 0.0v 4.755n 0.0v 9.745n 0.0v 9.755n 0.0v 14.745n 0.0v 14.755n 1.1v 19.745n 1.1v 19.755n 1.1v 24.745n 1.1v 24.755n 1.1v 29.745n 1.1v 29.755n 0.0v 34.745n 0.0v 34.755n 1.1v 39.745n 1.1v 39.755n 0.0v 44.745n 0.0v 44.755n 0.0v 49.745n 0.0v 49.755n 0.0v 54.745n 0.0v 54.755n 0.0v 59.745n 0.0v 59.755n 1.1v 64.745n 1.1v 64.755n 1.1v 69.745n 1.1v 69.755n 0.0v 74.745n 0.0v 74.755n 0.0v 79.745n 0.0v 79.755n 0.0v 84.745n 0.0v 84.755n 0.0v 89.745n 0.0v 89.755n 0.0v 94.745n 0.0v 94.755n 0.0v 99.745n 0.0v 99.755n 0.0v 104.745n 0.0v 104.755n 0.0v 109.745n 0.0v 109.755n 0.0v 114.745n 0.0v 114.755n 1.1v 119.745n 1.1v 119.755n 1.1v 124.745n 1.1v 124.755n 1.1v 129.745n 1.1v 129.755n 1.1v 134.745n 1.1v 134.755n 0.0v 139.745n 0.0v 139.755n 1.1v 144.745n 1.1v 144.755n 1.1v 149.745n 1.1v 149.755n 1.1v 154.745n 1.1v 154.755n 1.1v 159.745n 1.1v 159.755n 1.1v 164.745n 1.1v 164.755n 0.0v 169.745n 0.0v 169.755n 0.0v 174.745n 0.0v 174.755n 0.0v 179.745n 0.0v 179.755n 0.0v 184.745n 0.0v 184.755n 0.0v 189.745n 0.0v 189.755n 0.0v 194.745n 0.0v 194.755n 0.0v 199.745n 0.0v 199.755n 1.1v 204.745n 1.1v 204.755n 1.1v 209.745n 1.1v 209.755n 1.1v 214.745n 1.1v 214.755n 1.1v 219.745n 1.1v 219.755n 0.0v 224.745n 0.0v 224.755n 0.0v 229.745n 0.0v 229.755n 1.1v 234.745n 1.1v 234.755n 1.1v 239.745n 1.1v 239.755n 1.1v 244.745n 1.1v 244.755n 0.0v 249.745n 0.0v 249.755n 0.0v 254.745n 0.0v 254.755n 0.0v 259.745n 0.0v 259.755n 0.0v 264.745n 0.0v 264.755n 0.0v 269.745n 0.0v 269.755n 1.1v 274.745n 1.1v 274.755n 1.1v 279.745n 1.1v 279.755n 1.1v 284.745n 1.1v 284.755n 1.1v 289.745n 1.1v 289.755n 1.1v 294.745n 1.1v 294.755n 1.1v 299.745n 1.1v 299.755n 1.1v 304.745n 1.1v 304.755n 1.1v 309.745n 1.1v 309.755n 1.1v 314.745n 1.1v 314.755n 1.1v 319.745n 1.1v 319.755n 1.1v 324.745n 1.1v 324.755n 0.0v 329.745n 0.0v 329.755n 1.1v 334.745n 1.1v 334.755n 1.1v 339.745n 1.1v 339.755n 1.1v 344.745n 1.1v 344.755n 1.1v 349.745n 1.1v 349.755n 1.1v 354.745n 1.1v 354.755n 1.1v 359.745n 1.1v 359.755n 1.1v 364.745n 1.1v 364.755n 1.1v 369.745n 1.1v 369.755n 1.1v 374.745n 1.1v 374.755n 0.0v 379.745n 0.0v 379.755n 0.0v 384.745n 0.0v 384.755n 0.0v 389.745n 0.0v 389.755n 0.0v 394.745n 0.0v 394.755n 0.0v 399.745n 0.0v 399.755n 0.0v 404.745n 0.0v 404.755n 0.0v 409.745n 0.0v 409.755n 0.0v 414.745n 0.0v 414.755n 1.1v 419.745n 1.1v 419.755n 1.1v 424.745n 1.1v 424.755n 1.1v 429.745n 1.1v 429.755n 1.1v 434.745n 1.1v 434.755n 1.1v 439.745n 1.1v 439.755n 1.1v 444.745n 1.1v 444.755n 1.1v 449.745n 1.1v 449.755n 1.1v 454.745n 1.1v 454.755n 1.1v 459.745n 1.1v 459.755n 1.1v 464.745n 1.1v 464.755n 1.1v 469.745n 1.1v 469.755n 1.1v 474.745n 1.1v 474.755n 1.1v 479.745n 1.1v 479.755n 0.0v 484.745n 0.0v 484.755n 1.1v 489.745n 1.1v 489.755n 1.1v 494.745n 1.1v 494.755n 0.0v 499.745n 0.0v 499.755n 0.0v 504.745n 0.0v 504.755n 0.0v 509.745n 0.0v 509.755n 0.0v 514.745n 0.0v 514.755n 0.0v 519.745n 0.0v 519.755n 0.0v 524.745n 0.0v 524.755n 0.0v 529.745n 0.0v 529.755n 0.0v 534.745n 0.0v 534.755n 1.1v 539.745n 1.1v 539.755n 0.0v 544.745n 0.0v 544.755n 0.0v 549.745n 0.0v 549.755n 0.0v 554.745n 0.0v 554.755n 0.0v 559.745n 0.0v 559.755n 0.0v 564.745n 0.0v 564.755n 0.0v 569.745n 0.0v 569.755n 1.1v 574.745n 1.1v 574.755n 1.1v 579.745n 1.1v 579.755n 1.1v 584.745n 1.1v 584.755n 0.0v 589.745n 0.0v 589.755n 0.0v 594.745n 0.0v 594.755n 0.0v 599.745n 0.0v 599.755n 0.0v 604.745n 0.0v 604.755n 0.0v 609.745n 0.0v 609.755n 0.0v 614.745n 0.0v 614.755n 0.0v 619.745n 0.0v 619.755n 1.1v 624.745n 1.1v 624.755n 1.1v 629.745n 1.1v 629.755n 1.1v 634.745n 1.1v 634.755n 1.1v 639.745n 1.1v 639.755n 1.1v 644.745n 1.1v 644.755n 1.1v 649.745n 1.1v 649.755n 0.0v 654.745n 0.0v 654.755n 0.0v 659.745n 0.0v 659.755n 0.0v 664.745n 0.0v 664.755n 0.0v 669.745n 0.0v 669.755n 0.0v 674.745n 0.0v 674.755n 0.0v 679.745n 0.0v 679.755n 0.0v 684.745n 0.0v 684.755n 0.0v 689.745n 0.0v 689.755n 1.1v 694.745n 1.1v 694.755n 1.1v 699.745n 1.1v 699.755n 1.1v 704.745n 1.1v 704.755n 1.1v 709.745n 1.1v 709.755n 1.1v 714.745n 1.1v 714.755n 0.0v 719.745n 0.0v 719.755n 0.0v 724.745n 0.0v 724.755n 1.1v 729.745n 1.1v 729.755n 1.1v 734.745n 1.1v 734.755n 1.1v 739.745n 1.1v 739.755n 1.1v 744.745n 1.1v 744.755n 1.1v 749.745n 1.1v 749.755n 1.1v 754.745n 1.1v 754.755n 1.1v 759.745n 1.1v 759.755n 1.1v 764.745n 1.1v 764.755n 1.1v 769.745n 1.1v 769.755n 1.1v 774.745n 1.1v 774.755n 1.1v 779.745n 1.1v 779.755n 1.1v 784.745n 1.1v 784.755n 1.1v 789.745n 1.1v 789.755n 1.1v 794.745n 1.1v 794.755n 1.1v 799.745n 1.1v 799.755n 1.1v 804.745n 1.1v 804.755n 1.1v 809.745n 1.1v 809.755n 1.1v 814.745n 1.1v 814.755n 1.1v 819.745n 1.1v 819.755n 1.1v 824.745n 1.1v 824.755n 1.1v 829.745n 1.1v 829.755n 1.1v 834.745n 1.1v 834.755n 1.1v 839.745n 1.1v 839.755n 0.0v 844.745n 0.0v 844.755n 0.0v 849.745n 0.0v 849.755n 0.0v 854.745n 0.0v 854.755n 0.0v 859.745n 0.0v 859.755n 0.0v 864.745n 0.0v 864.755n 0.0v 869.745n 0.0v 869.755n 0.0v 874.745n 0.0v 874.755n 0.0v 879.745n 0.0v 879.755n 0.0v 884.745n 0.0v 884.755n 0.0v 889.745n 0.0v 889.755n 0.0v 894.745n 0.0v 894.755n 1.1v 899.745n 1.1v 899.755n 1.1v 904.745n 1.1v 904.755n 1.1v 909.745n 1.1v 909.755n 1.1v 914.745n 1.1v 914.755n 1.1v 919.745n 1.1v 919.755n 1.1v 924.745n 1.1v 924.755n 1.1v 929.745n 1.1v 929.755n 1.1v 934.745n 1.1v 934.755n 1.1v 939.745n 1.1v 939.755n 0.0v 944.745n 0.0v 944.755n 0.0v 949.745n 0.0v 949.755n 0.0v 954.745n 0.0v 954.755n 0.0v 959.745n 0.0v 959.755n 0.0v 964.745n 0.0v 964.755n 0.0v 969.745n 0.0v 969.755n 0.0v 974.745n 0.0v 974.755n 0.0v 979.745n 0.0v 979.755n 0.0v 984.745n 0.0v 984.755n 0.0v 989.745n 0.0v 989.755n 0.0v 994.745n 0.0v 994.755n 0.0v 999.745n 0.0v 999.755n 0.0v 1004.745n 0.0v 1004.755n 0.0v 1009.745n 0.0v 1009.755n 0.0v 1014.745n 0.0v 1014.755n 1.1v 1019.745n 1.1v 1019.755n 0.0v 1024.745n 0.0v 1024.755n 0.0v )
* (time, data): [(0, 0), (5, 1), (10, 1), (15, 1), (20, 1), (25, 1), (30, 0), (35, 0), (40, 1), (45, 1), (50, 1), (55, 1), (60, 1), (65, 1), (70, 0), (75, 0), (80, 0), (85, 0), (90, 0), (95, 0), (100, 0), (105, 0), (110, 0), (115, 1), (120, 1), (125, 0), (130, 0), (135, 1), (140, 0), (145, 0), (150, 0), (155, 0), (160, 0), (165, 1), (170, 1), (175, 1), (180, 1), (185, 1), (190, 1), (195, 1), (200, 1), (205, 1), (210, 1), (215, 1), (220, 1), (225, 1), (230, 0), (235, 0), (240, 0), (245, 1), (250, 1), (255, 1), (260, 1), (265, 1), (270, 0), (275, 0), (280, 0), (285, 0), (290, 0), (295, 0), (300, 0), (305, 1), (310, 1), (315, 1), (320, 1), (325, 0), (330, 0), (335, 0), (340, 0), (345, 0), (350, 0), (355, 0), (360, 0), (365, 0), (370, 1), (375, 1), (380, 1), (385, 0), (390, 0), (395, 0), (400, 0), (405, 0), (410, 0), (415, 1), (420, 1), (425, 1), (430, 1), (435, 1), (440, 1), (445, 1), (450, 1), (455, 1), (460, 1), (465, 1), (470, 1), (475, 1), (480, 0), (485, 0), (490, 0), (495, 1), (500, 1), (505, 1), (510, 1), (515, 1), (520, 1), (525, 1), (530, 1), (535, 1), (540, 0), (545, 0), (550, 0), (555, 1), (560, 1), (565, 1), (570, 0), (575, 0), (580, 0), (585, 1), (590, 1), (595, 1), (600, 0), (605, 0), (610, 0), (615, 0), (620, 1), (625, 1), (630, 1), (635, 1), (640, 1), (645, 1), (650, 1), (655, 1), (660, 1), (665, 1), (670, 1), (675, 1), (680, 1), (685, 1), (690, 1), (695, 1), (700, 1), (705, 1), (710, 1), (715, 0), (720, 0), (725, 1), (730, 1), (735, 1), (740, 1), (745, 1), (750, 1), (755, 1), (760, 1), (765, 1), (770, 1), (775, 1), (780, 1), (785, 1), (790, 1), (795, 0), (800, 0), (805, 0), (810, 0), (815, 0), (820, 0), (825, 0), (830, 0), (835, 0), (840, 1), (845, 1), (850, 1), (855, 1), (860, 1), (865, 1), (870, 1), (875, 1), (880, 1), (885, 1), (890, 1), (895, 1), (900, 1), (905, 1), (910, 1), (915, 1), (920, 1), (925, 1), (930, 1), (935, 1), (940, 1), (945, 1), (950, 1), (955, 1), (960, 1), (965, 1), (970, 1), (975, 1), (980, 1), (985, 1), (990, 0), (995, 0), (1000, 0), (1005, 0), (1010, 0), (1015, 1), (1020, 0), (1025, 0)]
Vdin0_25  din0_25  0 PWL (0n 0.0v 4.745n 0.0v 4.755n 1.1v 9.745n 1.1v 9.755n 1.1v 14.745n 1.1v 14.755n 1.1v 19.745n 1.1v 19.755n 1.1v 24.745n 1.1v 24.755n 1.1v 29.745n 1.1v 29.755n 0.0v 34.745n 0.0v 34.755n 0.0v 39.745n 0.0v 39.755n 1.1v 44.745n 1.1v 44.755n 1.1v 49.745n 1.1v 49.755n 1.1v 54.745n 1.1v 54.755n 1.1v 59.745n 1.1v 59.755n 1.1v 64.745n 1.1v 64.755n 1.1v 69.745n 1.1v 69.755n 0.0v 74.745n 0.0v 74.755n 0.0v 79.745n 0.0v 79.755n 0.0v 84.745n 0.0v 84.755n 0.0v 89.745n 0.0v 89.755n 0.0v 94.745n 0.0v 94.755n 0.0v 99.745n 0.0v 99.755n 0.0v 104.745n 0.0v 104.755n 0.0v 109.745n 0.0v 109.755n 0.0v 114.745n 0.0v 114.755n 1.1v 119.745n 1.1v 119.755n 1.1v 124.745n 1.1v 124.755n 0.0v 129.745n 0.0v 129.755n 0.0v 134.745n 0.0v 134.755n 1.1v 139.745n 1.1v 139.755n 0.0v 144.745n 0.0v 144.755n 0.0v 149.745n 0.0v 149.755n 0.0v 154.745n 0.0v 154.755n 0.0v 159.745n 0.0v 159.755n 0.0v 164.745n 0.0v 164.755n 1.1v 169.745n 1.1v 169.755n 1.1v 174.745n 1.1v 174.755n 1.1v 179.745n 1.1v 179.755n 1.1v 184.745n 1.1v 184.755n 1.1v 189.745n 1.1v 189.755n 1.1v 194.745n 1.1v 194.755n 1.1v 199.745n 1.1v 199.755n 1.1v 204.745n 1.1v 204.755n 1.1v 209.745n 1.1v 209.755n 1.1v 214.745n 1.1v 214.755n 1.1v 219.745n 1.1v 219.755n 1.1v 224.745n 1.1v 224.755n 1.1v 229.745n 1.1v 229.755n 0.0v 234.745n 0.0v 234.755n 0.0v 239.745n 0.0v 239.755n 0.0v 244.745n 0.0v 244.755n 1.1v 249.745n 1.1v 249.755n 1.1v 254.745n 1.1v 254.755n 1.1v 259.745n 1.1v 259.755n 1.1v 264.745n 1.1v 264.755n 1.1v 269.745n 1.1v 269.755n 0.0v 274.745n 0.0v 274.755n 0.0v 279.745n 0.0v 279.755n 0.0v 284.745n 0.0v 284.755n 0.0v 289.745n 0.0v 289.755n 0.0v 294.745n 0.0v 294.755n 0.0v 299.745n 0.0v 299.755n 0.0v 304.745n 0.0v 304.755n 1.1v 309.745n 1.1v 309.755n 1.1v 314.745n 1.1v 314.755n 1.1v 319.745n 1.1v 319.755n 1.1v 324.745n 1.1v 324.755n 0.0v 329.745n 0.0v 329.755n 0.0v 334.745n 0.0v 334.755n 0.0v 339.745n 0.0v 339.755n 0.0v 344.745n 0.0v 344.755n 0.0v 349.745n 0.0v 349.755n 0.0v 354.745n 0.0v 354.755n 0.0v 359.745n 0.0v 359.755n 0.0v 364.745n 0.0v 364.755n 0.0v 369.745n 0.0v 369.755n 1.1v 374.745n 1.1v 374.755n 1.1v 379.745n 1.1v 379.755n 1.1v 384.745n 1.1v 384.755n 0.0v 389.745n 0.0v 389.755n 0.0v 394.745n 0.0v 394.755n 0.0v 399.745n 0.0v 399.755n 0.0v 404.745n 0.0v 404.755n 0.0v 409.745n 0.0v 409.755n 0.0v 414.745n 0.0v 414.755n 1.1v 419.745n 1.1v 419.755n 1.1v 424.745n 1.1v 424.755n 1.1v 429.745n 1.1v 429.755n 1.1v 434.745n 1.1v 434.755n 1.1v 439.745n 1.1v 439.755n 1.1v 444.745n 1.1v 444.755n 1.1v 449.745n 1.1v 449.755n 1.1v 454.745n 1.1v 454.755n 1.1v 459.745n 1.1v 459.755n 1.1v 464.745n 1.1v 464.755n 1.1v 469.745n 1.1v 469.755n 1.1v 474.745n 1.1v 474.755n 1.1v 479.745n 1.1v 479.755n 0.0v 484.745n 0.0v 484.755n 0.0v 489.745n 0.0v 489.755n 0.0v 494.745n 0.0v 494.755n 1.1v 499.745n 1.1v 499.755n 1.1v 504.745n 1.1v 504.755n 1.1v 509.745n 1.1v 509.755n 1.1v 514.745n 1.1v 514.755n 1.1v 519.745n 1.1v 519.755n 1.1v 524.745n 1.1v 524.755n 1.1v 529.745n 1.1v 529.755n 1.1v 534.745n 1.1v 534.755n 1.1v 539.745n 1.1v 539.755n 0.0v 544.745n 0.0v 544.755n 0.0v 549.745n 0.0v 549.755n 0.0v 554.745n 0.0v 554.755n 1.1v 559.745n 1.1v 559.755n 1.1v 564.745n 1.1v 564.755n 1.1v 569.745n 1.1v 569.755n 0.0v 574.745n 0.0v 574.755n 0.0v 579.745n 0.0v 579.755n 0.0v 584.745n 0.0v 584.755n 1.1v 589.745n 1.1v 589.755n 1.1v 594.745n 1.1v 594.755n 1.1v 599.745n 1.1v 599.755n 0.0v 604.745n 0.0v 604.755n 0.0v 609.745n 0.0v 609.755n 0.0v 614.745n 0.0v 614.755n 0.0v 619.745n 0.0v 619.755n 1.1v 624.745n 1.1v 624.755n 1.1v 629.745n 1.1v 629.755n 1.1v 634.745n 1.1v 634.755n 1.1v 639.745n 1.1v 639.755n 1.1v 644.745n 1.1v 644.755n 1.1v 649.745n 1.1v 649.755n 1.1v 654.745n 1.1v 654.755n 1.1v 659.745n 1.1v 659.755n 1.1v 664.745n 1.1v 664.755n 1.1v 669.745n 1.1v 669.755n 1.1v 674.745n 1.1v 674.755n 1.1v 679.745n 1.1v 679.755n 1.1v 684.745n 1.1v 684.755n 1.1v 689.745n 1.1v 689.755n 1.1v 694.745n 1.1v 694.755n 1.1v 699.745n 1.1v 699.755n 1.1v 704.745n 1.1v 704.755n 1.1v 709.745n 1.1v 709.755n 1.1v 714.745n 1.1v 714.755n 0.0v 719.745n 0.0v 719.755n 0.0v 724.745n 0.0v 724.755n 1.1v 729.745n 1.1v 729.755n 1.1v 734.745n 1.1v 734.755n 1.1v 739.745n 1.1v 739.755n 1.1v 744.745n 1.1v 744.755n 1.1v 749.745n 1.1v 749.755n 1.1v 754.745n 1.1v 754.755n 1.1v 759.745n 1.1v 759.755n 1.1v 764.745n 1.1v 764.755n 1.1v 769.745n 1.1v 769.755n 1.1v 774.745n 1.1v 774.755n 1.1v 779.745n 1.1v 779.755n 1.1v 784.745n 1.1v 784.755n 1.1v 789.745n 1.1v 789.755n 1.1v 794.745n 1.1v 794.755n 0.0v 799.745n 0.0v 799.755n 0.0v 804.745n 0.0v 804.755n 0.0v 809.745n 0.0v 809.755n 0.0v 814.745n 0.0v 814.755n 0.0v 819.745n 0.0v 819.755n 0.0v 824.745n 0.0v 824.755n 0.0v 829.745n 0.0v 829.755n 0.0v 834.745n 0.0v 834.755n 0.0v 839.745n 0.0v 839.755n 1.1v 844.745n 1.1v 844.755n 1.1v 849.745n 1.1v 849.755n 1.1v 854.745n 1.1v 854.755n 1.1v 859.745n 1.1v 859.755n 1.1v 864.745n 1.1v 864.755n 1.1v 869.745n 1.1v 869.755n 1.1v 874.745n 1.1v 874.755n 1.1v 879.745n 1.1v 879.755n 1.1v 884.745n 1.1v 884.755n 1.1v 889.745n 1.1v 889.755n 1.1v 894.745n 1.1v 894.755n 1.1v 899.745n 1.1v 899.755n 1.1v 904.745n 1.1v 904.755n 1.1v 909.745n 1.1v 909.755n 1.1v 914.745n 1.1v 914.755n 1.1v 919.745n 1.1v 919.755n 1.1v 924.745n 1.1v 924.755n 1.1v 929.745n 1.1v 929.755n 1.1v 934.745n 1.1v 934.755n 1.1v 939.745n 1.1v 939.755n 1.1v 944.745n 1.1v 944.755n 1.1v 949.745n 1.1v 949.755n 1.1v 954.745n 1.1v 954.755n 1.1v 959.745n 1.1v 959.755n 1.1v 964.745n 1.1v 964.755n 1.1v 969.745n 1.1v 969.755n 1.1v 974.745n 1.1v 974.755n 1.1v 979.745n 1.1v 979.755n 1.1v 984.745n 1.1v 984.755n 1.1v 989.745n 1.1v 989.755n 0.0v 994.745n 0.0v 994.755n 0.0v 999.745n 0.0v 999.755n 0.0v 1004.745n 0.0v 1004.755n 0.0v 1009.745n 0.0v 1009.755n 0.0v 1014.745n 0.0v 1014.755n 1.1v 1019.745n 1.1v 1019.755n 0.0v 1024.745n 0.0v 1024.755n 0.0v )
* (time, data): [(0, 0), (5, 0), (10, 1), (15, 1), (20, 1), (25, 1), (30, 0), (35, 0), (40, 0), (45, 0), (50, 0), (55, 0), (60, 1), (65, 1), (70, 1), (75, 1), (80, 1), (85, 1), (90, 1), (95, 1), (100, 0), (105, 0), (110, 0), (115, 1), (120, 1), (125, 0), (130, 0), (135, 1), (140, 1), (145, 1), (150, 1), (155, 1), (160, 1), (165, 1), (170, 1), (175, 1), (180, 1), (185, 1), (190, 1), (195, 1), (200, 0), (205, 0), (210, 0), (215, 0), (220, 1), (225, 1), (230, 0), (235, 0), (240, 0), (245, 1), (250, 1), (255, 1), (260, 1), (265, 1), (270, 0), (275, 0), (280, 0), (285, 1), (290, 1), (295, 1), (300, 1), (305, 0), (310, 0), (315, 0), (320, 0), (325, 1), (330, 0), (335, 0), (340, 0), (345, 0), (350, 0), (355, 0), (360, 0), (365, 0), (370, 1), (375, 1), (380, 1), (385, 0), (390, 0), (395, 0), (400, 0), (405, 0), (410, 0), (415, 0), (420, 0), (425, 0), (430, 1), (435, 1), (440, 1), (445, 1), (450, 1), (455, 1), (460, 1), (465, 1), (470, 1), (475, 1), (480, 1), (485, 1), (490, 1), (495, 1), (500, 1), (505, 1), (510, 1), (515, 1), (520, 1), (525, 1), (530, 1), (535, 0), (540, 1), (545, 1), (550, 1), (555, 1), (560, 1), (565, 1), (570, 0), (575, 0), (580, 0), (585, 1), (590, 1), (595, 1), (600, 0), (605, 0), (610, 0), (615, 0), (620, 1), (625, 1), (630, 1), (635, 1), (640, 1), (645, 1), (650, 1), (655, 1), (660, 1), (665, 1), (670, 1), (675, 1), (680, 1), (685, 1), (690, 0), (695, 0), (700, 0), (705, 0), (710, 0), (715, 0), (720, 0), (725, 1), (730, 1), (735, 1), (740, 1), (745, 1), (750, 1), (755, 1), (760, 1), (765, 1), (770, 1), (775, 1), (780, 1), (785, 1), (790, 1), (795, 0), (800, 0), (805, 0), (810, 0), (815, 0), (820, 0), (825, 0), (830, 0), (835, 0), (840, 0), (845, 0), (850, 0), (855, 0), (860, 0), (865, 0), (870, 0), (875, 0), (880, 0), (885, 0), (890, 0), (895, 0), (900, 0), (905, 0), (910, 0), (915, 0), (920, 1), (925, 1), (930, 1), (935, 1), (940, 0), (945, 0), (950, 0), (955, 0), (960, 0), (965, 0), (970, 0), (975, 0), (980, 0), (985, 0), (990, 1), (995, 1), (1000, 1), (1005, 1), (1010, 1), (1015, 0), (1020, 0), (1025, 0)]
Vdin0_26  din0_26  0 PWL (0n 0.0v 4.745n 0.0v 4.755n 0.0v 9.745n 0.0v 9.755n 1.1v 14.745n 1.1v 14.755n 1.1v 19.745n 1.1v 19.755n 1.1v 24.745n 1.1v 24.755n 1.1v 29.745n 1.1v 29.755n 0.0v 34.745n 0.0v 34.755n 0.0v 39.745n 0.0v 39.755n 0.0v 44.745n 0.0v 44.755n 0.0v 49.745n 0.0v 49.755n 0.0v 54.745n 0.0v 54.755n 0.0v 59.745n 0.0v 59.755n 1.1v 64.745n 1.1v 64.755n 1.1v 69.745n 1.1v 69.755n 1.1v 74.745n 1.1v 74.755n 1.1v 79.745n 1.1v 79.755n 1.1v 84.745n 1.1v 84.755n 1.1v 89.745n 1.1v 89.755n 1.1v 94.745n 1.1v 94.755n 1.1v 99.745n 1.1v 99.755n 0.0v 104.745n 0.0v 104.755n 0.0v 109.745n 0.0v 109.755n 0.0v 114.745n 0.0v 114.755n 1.1v 119.745n 1.1v 119.755n 1.1v 124.745n 1.1v 124.755n 0.0v 129.745n 0.0v 129.755n 0.0v 134.745n 0.0v 134.755n 1.1v 139.745n 1.1v 139.755n 1.1v 144.745n 1.1v 144.755n 1.1v 149.745n 1.1v 149.755n 1.1v 154.745n 1.1v 154.755n 1.1v 159.745n 1.1v 159.755n 1.1v 164.745n 1.1v 164.755n 1.1v 169.745n 1.1v 169.755n 1.1v 174.745n 1.1v 174.755n 1.1v 179.745n 1.1v 179.755n 1.1v 184.745n 1.1v 184.755n 1.1v 189.745n 1.1v 189.755n 1.1v 194.745n 1.1v 194.755n 1.1v 199.745n 1.1v 199.755n 0.0v 204.745n 0.0v 204.755n 0.0v 209.745n 0.0v 209.755n 0.0v 214.745n 0.0v 214.755n 0.0v 219.745n 0.0v 219.755n 1.1v 224.745n 1.1v 224.755n 1.1v 229.745n 1.1v 229.755n 0.0v 234.745n 0.0v 234.755n 0.0v 239.745n 0.0v 239.755n 0.0v 244.745n 0.0v 244.755n 1.1v 249.745n 1.1v 249.755n 1.1v 254.745n 1.1v 254.755n 1.1v 259.745n 1.1v 259.755n 1.1v 264.745n 1.1v 264.755n 1.1v 269.745n 1.1v 269.755n 0.0v 274.745n 0.0v 274.755n 0.0v 279.745n 0.0v 279.755n 0.0v 284.745n 0.0v 284.755n 1.1v 289.745n 1.1v 289.755n 1.1v 294.745n 1.1v 294.755n 1.1v 299.745n 1.1v 299.755n 1.1v 304.745n 1.1v 304.755n 0.0v 309.745n 0.0v 309.755n 0.0v 314.745n 0.0v 314.755n 0.0v 319.745n 0.0v 319.755n 0.0v 324.745n 0.0v 324.755n 1.1v 329.745n 1.1v 329.755n 0.0v 334.745n 0.0v 334.755n 0.0v 339.745n 0.0v 339.755n 0.0v 344.745n 0.0v 344.755n 0.0v 349.745n 0.0v 349.755n 0.0v 354.745n 0.0v 354.755n 0.0v 359.745n 0.0v 359.755n 0.0v 364.745n 0.0v 364.755n 0.0v 369.745n 0.0v 369.755n 1.1v 374.745n 1.1v 374.755n 1.1v 379.745n 1.1v 379.755n 1.1v 384.745n 1.1v 384.755n 0.0v 389.745n 0.0v 389.755n 0.0v 394.745n 0.0v 394.755n 0.0v 399.745n 0.0v 399.755n 0.0v 404.745n 0.0v 404.755n 0.0v 409.745n 0.0v 409.755n 0.0v 414.745n 0.0v 414.755n 0.0v 419.745n 0.0v 419.755n 0.0v 424.745n 0.0v 424.755n 0.0v 429.745n 0.0v 429.755n 1.1v 434.745n 1.1v 434.755n 1.1v 439.745n 1.1v 439.755n 1.1v 444.745n 1.1v 444.755n 1.1v 449.745n 1.1v 449.755n 1.1v 454.745n 1.1v 454.755n 1.1v 459.745n 1.1v 459.755n 1.1v 464.745n 1.1v 464.755n 1.1v 469.745n 1.1v 469.755n 1.1v 474.745n 1.1v 474.755n 1.1v 479.745n 1.1v 479.755n 1.1v 484.745n 1.1v 484.755n 1.1v 489.745n 1.1v 489.755n 1.1v 494.745n 1.1v 494.755n 1.1v 499.745n 1.1v 499.755n 1.1v 504.745n 1.1v 504.755n 1.1v 509.745n 1.1v 509.755n 1.1v 514.745n 1.1v 514.755n 1.1v 519.745n 1.1v 519.755n 1.1v 524.745n 1.1v 524.755n 1.1v 529.745n 1.1v 529.755n 1.1v 534.745n 1.1v 534.755n 0.0v 539.745n 0.0v 539.755n 1.1v 544.745n 1.1v 544.755n 1.1v 549.745n 1.1v 549.755n 1.1v 554.745n 1.1v 554.755n 1.1v 559.745n 1.1v 559.755n 1.1v 564.745n 1.1v 564.755n 1.1v 569.745n 1.1v 569.755n 0.0v 574.745n 0.0v 574.755n 0.0v 579.745n 0.0v 579.755n 0.0v 584.745n 0.0v 584.755n 1.1v 589.745n 1.1v 589.755n 1.1v 594.745n 1.1v 594.755n 1.1v 599.745n 1.1v 599.755n 0.0v 604.745n 0.0v 604.755n 0.0v 609.745n 0.0v 609.755n 0.0v 614.745n 0.0v 614.755n 0.0v 619.745n 0.0v 619.755n 1.1v 624.745n 1.1v 624.755n 1.1v 629.745n 1.1v 629.755n 1.1v 634.745n 1.1v 634.755n 1.1v 639.745n 1.1v 639.755n 1.1v 644.745n 1.1v 644.755n 1.1v 649.745n 1.1v 649.755n 1.1v 654.745n 1.1v 654.755n 1.1v 659.745n 1.1v 659.755n 1.1v 664.745n 1.1v 664.755n 1.1v 669.745n 1.1v 669.755n 1.1v 674.745n 1.1v 674.755n 1.1v 679.745n 1.1v 679.755n 1.1v 684.745n 1.1v 684.755n 1.1v 689.745n 1.1v 689.755n 0.0v 694.745n 0.0v 694.755n 0.0v 699.745n 0.0v 699.755n 0.0v 704.745n 0.0v 704.755n 0.0v 709.745n 0.0v 709.755n 0.0v 714.745n 0.0v 714.755n 0.0v 719.745n 0.0v 719.755n 0.0v 724.745n 0.0v 724.755n 1.1v 729.745n 1.1v 729.755n 1.1v 734.745n 1.1v 734.755n 1.1v 739.745n 1.1v 739.755n 1.1v 744.745n 1.1v 744.755n 1.1v 749.745n 1.1v 749.755n 1.1v 754.745n 1.1v 754.755n 1.1v 759.745n 1.1v 759.755n 1.1v 764.745n 1.1v 764.755n 1.1v 769.745n 1.1v 769.755n 1.1v 774.745n 1.1v 774.755n 1.1v 779.745n 1.1v 779.755n 1.1v 784.745n 1.1v 784.755n 1.1v 789.745n 1.1v 789.755n 1.1v 794.745n 1.1v 794.755n 0.0v 799.745n 0.0v 799.755n 0.0v 804.745n 0.0v 804.755n 0.0v 809.745n 0.0v 809.755n 0.0v 814.745n 0.0v 814.755n 0.0v 819.745n 0.0v 819.755n 0.0v 824.745n 0.0v 824.755n 0.0v 829.745n 0.0v 829.755n 0.0v 834.745n 0.0v 834.755n 0.0v 839.745n 0.0v 839.755n 0.0v 844.745n 0.0v 844.755n 0.0v 849.745n 0.0v 849.755n 0.0v 854.745n 0.0v 854.755n 0.0v 859.745n 0.0v 859.755n 0.0v 864.745n 0.0v 864.755n 0.0v 869.745n 0.0v 869.755n 0.0v 874.745n 0.0v 874.755n 0.0v 879.745n 0.0v 879.755n 0.0v 884.745n 0.0v 884.755n 0.0v 889.745n 0.0v 889.755n 0.0v 894.745n 0.0v 894.755n 0.0v 899.745n 0.0v 899.755n 0.0v 904.745n 0.0v 904.755n 0.0v 909.745n 0.0v 909.755n 0.0v 914.745n 0.0v 914.755n 0.0v 919.745n 0.0v 919.755n 1.1v 924.745n 1.1v 924.755n 1.1v 929.745n 1.1v 929.755n 1.1v 934.745n 1.1v 934.755n 1.1v 939.745n 1.1v 939.755n 0.0v 944.745n 0.0v 944.755n 0.0v 949.745n 0.0v 949.755n 0.0v 954.745n 0.0v 954.755n 0.0v 959.745n 0.0v 959.755n 0.0v 964.745n 0.0v 964.755n 0.0v 969.745n 0.0v 969.755n 0.0v 974.745n 0.0v 974.755n 0.0v 979.745n 0.0v 979.755n 0.0v 984.745n 0.0v 984.755n 0.0v 989.745n 0.0v 989.755n 1.1v 994.745n 1.1v 994.755n 1.1v 999.745n 1.1v 999.755n 1.1v 1004.745n 1.1v 1004.755n 1.1v 1009.745n 1.1v 1009.755n 1.1v 1014.745n 1.1v 1014.755n 0.0v 1019.745n 0.0v 1019.755n 0.0v 1024.745n 0.0v 1024.755n 0.0v )
* (time, data): [(0, 0), (5, 1), (10, 1), (15, 0), (20, 0), (25, 0), (30, 1), (35, 1), (40, 0), (45, 0), (50, 0), (55, 0), (60, 0), (65, 0), (70, 1), (75, 1), (80, 1), (85, 1), (90, 1), (95, 1), (100, 0), (105, 0), (110, 0), (115, 1), (120, 1), (125, 0), (130, 0), (135, 0), (140, 1), (145, 1), (150, 1), (155, 1), (160, 1), (165, 1), (170, 1), (175, 1), (180, 1), (185, 1), (190, 1), (195, 1), (200, 0), (205, 0), (210, 0), (215, 0), (220, 0), (225, 0), (230, 1), (235, 1), (240, 1), (245, 1), (250, 1), (255, 0), (260, 0), (265, 0), (270, 0), (275, 0), (280, 0), (285, 1), (290, 1), (295, 1), (300, 1), (305, 0), (310, 0), (315, 0), (320, 0), (325, 1), (330, 1), (335, 1), (340, 1), (345, 0), (350, 0), (355, 0), (360, 0), (365, 0), (370, 1), (375, 1), (380, 1), (385, 0), (390, 0), (395, 0), (400, 0), (405, 0), (410, 0), (415, 1), (420, 0), (425, 0), (430, 0), (435, 0), (440, 0), (445, 0), (450, 0), (455, 0), (460, 0), (465, 0), (470, 0), (475, 0), (480, 0), (485, 0), (490, 0), (495, 1), (500, 1), (505, 1), (510, 1), (515, 1), (520, 1), (525, 1), (530, 1), (535, 0), (540, 0), (545, 0), (550, 0), (555, 0), (560, 0), (565, 0), (570, 0), (575, 0), (580, 0), (585, 0), (590, 0), (595, 0), (600, 1), (605, 1), (610, 1), (615, 1), (620, 1), (625, 1), (630, 1), (635, 1), (640, 1), (645, 1), (650, 1), (655, 1), (660, 1), (665, 1), (670, 1), (675, 1), (680, 1), (685, 1), (690, 0), (695, 0), (700, 0), (705, 0), (710, 0), (715, 0), (720, 0), (725, 0), (730, 0), (735, 0), (740, 0), (745, 0), (750, 0), (755, 0), (760, 0), (765, 0), (770, 0), (775, 0), (780, 0), (785, 0), (790, 0), (795, 1), (800, 1), (805, 1), (810, 1), (815, 1), (820, 1), (825, 1), (830, 1), (835, 1), (840, 0), (845, 0), (850, 0), (855, 0), (860, 0), (865, 0), (870, 0), (875, 0), (880, 0), (885, 0), (890, 0), (895, 1), (900, 1), (905, 1), (910, 1), (915, 1), (920, 1), (925, 1), (930, 1), (935, 1), (940, 1), (945, 1), (950, 1), (955, 1), (960, 1), (965, 1), (970, 1), (975, 1), (980, 1), (985, 0), (990, 1), (995, 1), (1000, 1), (1005, 1), (1010, 1), (1015, 1), (1020, 1), (1025, 1)]
Vdin0_27  din0_27  0 PWL (0n 0.0v 4.745n 0.0v 4.755n 1.1v 9.745n 1.1v 9.755n 1.1v 14.745n 1.1v 14.755n 0.0v 19.745n 0.0v 19.755n 0.0v 24.745n 0.0v 24.755n 0.0v 29.745n 0.0v 29.755n 1.1v 34.745n 1.1v 34.755n 1.1v 39.745n 1.1v 39.755n 0.0v 44.745n 0.0v 44.755n 0.0v 49.745n 0.0v 49.755n 0.0v 54.745n 0.0v 54.755n 0.0v 59.745n 0.0v 59.755n 0.0v 64.745n 0.0v 64.755n 0.0v 69.745n 0.0v 69.755n 1.1v 74.745n 1.1v 74.755n 1.1v 79.745n 1.1v 79.755n 1.1v 84.745n 1.1v 84.755n 1.1v 89.745n 1.1v 89.755n 1.1v 94.745n 1.1v 94.755n 1.1v 99.745n 1.1v 99.755n 0.0v 104.745n 0.0v 104.755n 0.0v 109.745n 0.0v 109.755n 0.0v 114.745n 0.0v 114.755n 1.1v 119.745n 1.1v 119.755n 1.1v 124.745n 1.1v 124.755n 0.0v 129.745n 0.0v 129.755n 0.0v 134.745n 0.0v 134.755n 0.0v 139.745n 0.0v 139.755n 1.1v 144.745n 1.1v 144.755n 1.1v 149.745n 1.1v 149.755n 1.1v 154.745n 1.1v 154.755n 1.1v 159.745n 1.1v 159.755n 1.1v 164.745n 1.1v 164.755n 1.1v 169.745n 1.1v 169.755n 1.1v 174.745n 1.1v 174.755n 1.1v 179.745n 1.1v 179.755n 1.1v 184.745n 1.1v 184.755n 1.1v 189.745n 1.1v 189.755n 1.1v 194.745n 1.1v 194.755n 1.1v 199.745n 1.1v 199.755n 0.0v 204.745n 0.0v 204.755n 0.0v 209.745n 0.0v 209.755n 0.0v 214.745n 0.0v 214.755n 0.0v 219.745n 0.0v 219.755n 0.0v 224.745n 0.0v 224.755n 0.0v 229.745n 0.0v 229.755n 1.1v 234.745n 1.1v 234.755n 1.1v 239.745n 1.1v 239.755n 1.1v 244.745n 1.1v 244.755n 1.1v 249.745n 1.1v 249.755n 1.1v 254.745n 1.1v 254.755n 0.0v 259.745n 0.0v 259.755n 0.0v 264.745n 0.0v 264.755n 0.0v 269.745n 0.0v 269.755n 0.0v 274.745n 0.0v 274.755n 0.0v 279.745n 0.0v 279.755n 0.0v 284.745n 0.0v 284.755n 1.1v 289.745n 1.1v 289.755n 1.1v 294.745n 1.1v 294.755n 1.1v 299.745n 1.1v 299.755n 1.1v 304.745n 1.1v 304.755n 0.0v 309.745n 0.0v 309.755n 0.0v 314.745n 0.0v 314.755n 0.0v 319.745n 0.0v 319.755n 0.0v 324.745n 0.0v 324.755n 1.1v 329.745n 1.1v 329.755n 1.1v 334.745n 1.1v 334.755n 1.1v 339.745n 1.1v 339.755n 1.1v 344.745n 1.1v 344.755n 0.0v 349.745n 0.0v 349.755n 0.0v 354.745n 0.0v 354.755n 0.0v 359.745n 0.0v 359.755n 0.0v 364.745n 0.0v 364.755n 0.0v 369.745n 0.0v 369.755n 1.1v 374.745n 1.1v 374.755n 1.1v 379.745n 1.1v 379.755n 1.1v 384.745n 1.1v 384.755n 0.0v 389.745n 0.0v 389.755n 0.0v 394.745n 0.0v 394.755n 0.0v 399.745n 0.0v 399.755n 0.0v 404.745n 0.0v 404.755n 0.0v 409.745n 0.0v 409.755n 0.0v 414.745n 0.0v 414.755n 1.1v 419.745n 1.1v 419.755n 0.0v 424.745n 0.0v 424.755n 0.0v 429.745n 0.0v 429.755n 0.0v 434.745n 0.0v 434.755n 0.0v 439.745n 0.0v 439.755n 0.0v 444.745n 0.0v 444.755n 0.0v 449.745n 0.0v 449.755n 0.0v 454.745n 0.0v 454.755n 0.0v 459.745n 0.0v 459.755n 0.0v 464.745n 0.0v 464.755n 0.0v 469.745n 0.0v 469.755n 0.0v 474.745n 0.0v 474.755n 0.0v 479.745n 0.0v 479.755n 0.0v 484.745n 0.0v 484.755n 0.0v 489.745n 0.0v 489.755n 0.0v 494.745n 0.0v 494.755n 1.1v 499.745n 1.1v 499.755n 1.1v 504.745n 1.1v 504.755n 1.1v 509.745n 1.1v 509.755n 1.1v 514.745n 1.1v 514.755n 1.1v 519.745n 1.1v 519.755n 1.1v 524.745n 1.1v 524.755n 1.1v 529.745n 1.1v 529.755n 1.1v 534.745n 1.1v 534.755n 0.0v 539.745n 0.0v 539.755n 0.0v 544.745n 0.0v 544.755n 0.0v 549.745n 0.0v 549.755n 0.0v 554.745n 0.0v 554.755n 0.0v 559.745n 0.0v 559.755n 0.0v 564.745n 0.0v 564.755n 0.0v 569.745n 0.0v 569.755n 0.0v 574.745n 0.0v 574.755n 0.0v 579.745n 0.0v 579.755n 0.0v 584.745n 0.0v 584.755n 0.0v 589.745n 0.0v 589.755n 0.0v 594.745n 0.0v 594.755n 0.0v 599.745n 0.0v 599.755n 1.1v 604.745n 1.1v 604.755n 1.1v 609.745n 1.1v 609.755n 1.1v 614.745n 1.1v 614.755n 1.1v 619.745n 1.1v 619.755n 1.1v 624.745n 1.1v 624.755n 1.1v 629.745n 1.1v 629.755n 1.1v 634.745n 1.1v 634.755n 1.1v 639.745n 1.1v 639.755n 1.1v 644.745n 1.1v 644.755n 1.1v 649.745n 1.1v 649.755n 1.1v 654.745n 1.1v 654.755n 1.1v 659.745n 1.1v 659.755n 1.1v 664.745n 1.1v 664.755n 1.1v 669.745n 1.1v 669.755n 1.1v 674.745n 1.1v 674.755n 1.1v 679.745n 1.1v 679.755n 1.1v 684.745n 1.1v 684.755n 1.1v 689.745n 1.1v 689.755n 0.0v 694.745n 0.0v 694.755n 0.0v 699.745n 0.0v 699.755n 0.0v 704.745n 0.0v 704.755n 0.0v 709.745n 0.0v 709.755n 0.0v 714.745n 0.0v 714.755n 0.0v 719.745n 0.0v 719.755n 0.0v 724.745n 0.0v 724.755n 0.0v 729.745n 0.0v 729.755n 0.0v 734.745n 0.0v 734.755n 0.0v 739.745n 0.0v 739.755n 0.0v 744.745n 0.0v 744.755n 0.0v 749.745n 0.0v 749.755n 0.0v 754.745n 0.0v 754.755n 0.0v 759.745n 0.0v 759.755n 0.0v 764.745n 0.0v 764.755n 0.0v 769.745n 0.0v 769.755n 0.0v 774.745n 0.0v 774.755n 0.0v 779.745n 0.0v 779.755n 0.0v 784.745n 0.0v 784.755n 0.0v 789.745n 0.0v 789.755n 0.0v 794.745n 0.0v 794.755n 1.1v 799.745n 1.1v 799.755n 1.1v 804.745n 1.1v 804.755n 1.1v 809.745n 1.1v 809.755n 1.1v 814.745n 1.1v 814.755n 1.1v 819.745n 1.1v 819.755n 1.1v 824.745n 1.1v 824.755n 1.1v 829.745n 1.1v 829.755n 1.1v 834.745n 1.1v 834.755n 1.1v 839.745n 1.1v 839.755n 0.0v 844.745n 0.0v 844.755n 0.0v 849.745n 0.0v 849.755n 0.0v 854.745n 0.0v 854.755n 0.0v 859.745n 0.0v 859.755n 0.0v 864.745n 0.0v 864.755n 0.0v 869.745n 0.0v 869.755n 0.0v 874.745n 0.0v 874.755n 0.0v 879.745n 0.0v 879.755n 0.0v 884.745n 0.0v 884.755n 0.0v 889.745n 0.0v 889.755n 0.0v 894.745n 0.0v 894.755n 1.1v 899.745n 1.1v 899.755n 1.1v 904.745n 1.1v 904.755n 1.1v 909.745n 1.1v 909.755n 1.1v 914.745n 1.1v 914.755n 1.1v 919.745n 1.1v 919.755n 1.1v 924.745n 1.1v 924.755n 1.1v 929.745n 1.1v 929.755n 1.1v 934.745n 1.1v 934.755n 1.1v 939.745n 1.1v 939.755n 1.1v 944.745n 1.1v 944.755n 1.1v 949.745n 1.1v 949.755n 1.1v 954.745n 1.1v 954.755n 1.1v 959.745n 1.1v 959.755n 1.1v 964.745n 1.1v 964.755n 1.1v 969.745n 1.1v 969.755n 1.1v 974.745n 1.1v 974.755n 1.1v 979.745n 1.1v 979.755n 1.1v 984.745n 1.1v 984.755n 0.0v 989.745n 0.0v 989.755n 1.1v 994.745n 1.1v 994.755n 1.1v 999.745n 1.1v 999.755n 1.1v 1004.745n 1.1v 1004.755n 1.1v 1009.745n 1.1v 1009.755n 1.1v 1014.745n 1.1v 1014.755n 1.1v 1019.745n 1.1v 1019.755n 1.1v 1024.745n 1.1v 1024.755n 1.1v )
* (time, data): [(0, 0), (5, 1), (10, 1), (15, 0), (20, 0), (25, 0), (30, 0), (35, 0), (40, 0), (45, 0), (50, 0), (55, 0), (60, 0), (65, 0), (70, 1), (75, 1), (80, 1), (85, 1), (90, 1), (95, 1), (100, 0), (105, 0), (110, 0), (115, 1), (120, 1), (125, 1), (130, 1), (135, 0), (140, 0), (145, 0), (150, 0), (155, 0), (160, 0), (165, 1), (170, 1), (175, 1), (180, 1), (185, 1), (190, 1), (195, 1), (200, 1), (205, 1), (210, 1), (215, 1), (220, 1), (225, 1), (230, 0), (235, 0), (240, 0), (245, 0), (250, 0), (255, 0), (260, 0), (265, 0), (270, 1), (275, 1), (280, 1), (285, 0), (290, 0), (295, 0), (300, 0), (305, 0), (310, 0), (315, 0), (320, 0), (325, 1), (330, 1), (335, 1), (340, 1), (345, 0), (350, 0), (355, 0), (360, 0), (365, 0), (370, 0), (375, 1), (380, 1), (385, 0), (390, 0), (395, 0), (400, 0), (405, 0), (410, 0), (415, 0), (420, 1), (425, 1), (430, 0), (435, 0), (440, 0), (445, 0), (450, 0), (455, 0), (460, 0), (465, 0), (470, 0), (475, 0), (480, 0), (485, 1), (490, 1), (495, 0), (500, 0), (505, 0), (510, 0), (515, 0), (520, 0), (525, 0), (530, 0), (535, 1), (540, 1), (545, 1), (550, 1), (555, 0), (560, 0), (565, 0), (570, 0), (575, 0), (580, 0), (585, 0), (590, 0), (595, 0), (600, 0), (605, 0), (610, 0), (615, 0), (620, 1), (625, 1), (630, 1), (635, 1), (640, 1), (645, 1), (650, 0), (655, 1), (660, 1), (665, 1), (670, 1), (675, 1), (680, 1), (685, 1), (690, 0), (695, 0), (700, 0), (705, 0), (710, 0), (715, 1), (720, 1), (725, 1), (730, 1), (735, 1), (740, 1), (745, 1), (750, 1), (755, 1), (760, 1), (765, 1), (770, 1), (775, 1), (780, 1), (785, 1), (790, 1), (795, 1), (800, 1), (805, 1), (810, 1), (815, 1), (820, 1), (825, 1), (830, 1), (835, 1), (840, 0), (845, 0), (850, 0), (855, 0), (860, 0), (865, 0), (870, 1), (875, 1), (880, 1), (885, 1), (890, 1), (895, 0), (900, 0), (905, 0), (910, 0), (915, 0), (920, 0), (925, 0), (930, 0), (935, 0), (940, 0), (945, 0), (950, 0), (955, 0), (960, 0), (965, 0), (970, 0), (975, 0), (980, 0), (985, 0), (990, 0), (995, 0), (1000, 0), (1005, 0), (1010, 0), (1015, 0), (1020, 0), (1025, 0)]
Vdin0_28  din0_28  0 PWL (0n 0.0v 4.745n 0.0v 4.755n 1.1v 9.745n 1.1v 9.755n 1.1v 14.745n 1.1v 14.755n 0.0v 19.745n 0.0v 19.755n 0.0v 24.745n 0.0v 24.755n 0.0v 29.745n 0.0v 29.755n 0.0v 34.745n 0.0v 34.755n 0.0v 39.745n 0.0v 39.755n 0.0v 44.745n 0.0v 44.755n 0.0v 49.745n 0.0v 49.755n 0.0v 54.745n 0.0v 54.755n 0.0v 59.745n 0.0v 59.755n 0.0v 64.745n 0.0v 64.755n 0.0v 69.745n 0.0v 69.755n 1.1v 74.745n 1.1v 74.755n 1.1v 79.745n 1.1v 79.755n 1.1v 84.745n 1.1v 84.755n 1.1v 89.745n 1.1v 89.755n 1.1v 94.745n 1.1v 94.755n 1.1v 99.745n 1.1v 99.755n 0.0v 104.745n 0.0v 104.755n 0.0v 109.745n 0.0v 109.755n 0.0v 114.745n 0.0v 114.755n 1.1v 119.745n 1.1v 119.755n 1.1v 124.745n 1.1v 124.755n 1.1v 129.745n 1.1v 129.755n 1.1v 134.745n 1.1v 134.755n 0.0v 139.745n 0.0v 139.755n 0.0v 144.745n 0.0v 144.755n 0.0v 149.745n 0.0v 149.755n 0.0v 154.745n 0.0v 154.755n 0.0v 159.745n 0.0v 159.755n 0.0v 164.745n 0.0v 164.755n 1.1v 169.745n 1.1v 169.755n 1.1v 174.745n 1.1v 174.755n 1.1v 179.745n 1.1v 179.755n 1.1v 184.745n 1.1v 184.755n 1.1v 189.745n 1.1v 189.755n 1.1v 194.745n 1.1v 194.755n 1.1v 199.745n 1.1v 199.755n 1.1v 204.745n 1.1v 204.755n 1.1v 209.745n 1.1v 209.755n 1.1v 214.745n 1.1v 214.755n 1.1v 219.745n 1.1v 219.755n 1.1v 224.745n 1.1v 224.755n 1.1v 229.745n 1.1v 229.755n 0.0v 234.745n 0.0v 234.755n 0.0v 239.745n 0.0v 239.755n 0.0v 244.745n 0.0v 244.755n 0.0v 249.745n 0.0v 249.755n 0.0v 254.745n 0.0v 254.755n 0.0v 259.745n 0.0v 259.755n 0.0v 264.745n 0.0v 264.755n 0.0v 269.745n 0.0v 269.755n 1.1v 274.745n 1.1v 274.755n 1.1v 279.745n 1.1v 279.755n 1.1v 284.745n 1.1v 284.755n 0.0v 289.745n 0.0v 289.755n 0.0v 294.745n 0.0v 294.755n 0.0v 299.745n 0.0v 299.755n 0.0v 304.745n 0.0v 304.755n 0.0v 309.745n 0.0v 309.755n 0.0v 314.745n 0.0v 314.755n 0.0v 319.745n 0.0v 319.755n 0.0v 324.745n 0.0v 324.755n 1.1v 329.745n 1.1v 329.755n 1.1v 334.745n 1.1v 334.755n 1.1v 339.745n 1.1v 339.755n 1.1v 344.745n 1.1v 344.755n 0.0v 349.745n 0.0v 349.755n 0.0v 354.745n 0.0v 354.755n 0.0v 359.745n 0.0v 359.755n 0.0v 364.745n 0.0v 364.755n 0.0v 369.745n 0.0v 369.755n 0.0v 374.745n 0.0v 374.755n 1.1v 379.745n 1.1v 379.755n 1.1v 384.745n 1.1v 384.755n 0.0v 389.745n 0.0v 389.755n 0.0v 394.745n 0.0v 394.755n 0.0v 399.745n 0.0v 399.755n 0.0v 404.745n 0.0v 404.755n 0.0v 409.745n 0.0v 409.755n 0.0v 414.745n 0.0v 414.755n 0.0v 419.745n 0.0v 419.755n 1.1v 424.745n 1.1v 424.755n 1.1v 429.745n 1.1v 429.755n 0.0v 434.745n 0.0v 434.755n 0.0v 439.745n 0.0v 439.755n 0.0v 444.745n 0.0v 444.755n 0.0v 449.745n 0.0v 449.755n 0.0v 454.745n 0.0v 454.755n 0.0v 459.745n 0.0v 459.755n 0.0v 464.745n 0.0v 464.755n 0.0v 469.745n 0.0v 469.755n 0.0v 474.745n 0.0v 474.755n 0.0v 479.745n 0.0v 479.755n 0.0v 484.745n 0.0v 484.755n 1.1v 489.745n 1.1v 489.755n 1.1v 494.745n 1.1v 494.755n 0.0v 499.745n 0.0v 499.755n 0.0v 504.745n 0.0v 504.755n 0.0v 509.745n 0.0v 509.755n 0.0v 514.745n 0.0v 514.755n 0.0v 519.745n 0.0v 519.755n 0.0v 524.745n 0.0v 524.755n 0.0v 529.745n 0.0v 529.755n 0.0v 534.745n 0.0v 534.755n 1.1v 539.745n 1.1v 539.755n 1.1v 544.745n 1.1v 544.755n 1.1v 549.745n 1.1v 549.755n 1.1v 554.745n 1.1v 554.755n 0.0v 559.745n 0.0v 559.755n 0.0v 564.745n 0.0v 564.755n 0.0v 569.745n 0.0v 569.755n 0.0v 574.745n 0.0v 574.755n 0.0v 579.745n 0.0v 579.755n 0.0v 584.745n 0.0v 584.755n 0.0v 589.745n 0.0v 589.755n 0.0v 594.745n 0.0v 594.755n 0.0v 599.745n 0.0v 599.755n 0.0v 604.745n 0.0v 604.755n 0.0v 609.745n 0.0v 609.755n 0.0v 614.745n 0.0v 614.755n 0.0v 619.745n 0.0v 619.755n 1.1v 624.745n 1.1v 624.755n 1.1v 629.745n 1.1v 629.755n 1.1v 634.745n 1.1v 634.755n 1.1v 639.745n 1.1v 639.755n 1.1v 644.745n 1.1v 644.755n 1.1v 649.745n 1.1v 649.755n 0.0v 654.745n 0.0v 654.755n 1.1v 659.745n 1.1v 659.755n 1.1v 664.745n 1.1v 664.755n 1.1v 669.745n 1.1v 669.755n 1.1v 674.745n 1.1v 674.755n 1.1v 679.745n 1.1v 679.755n 1.1v 684.745n 1.1v 684.755n 1.1v 689.745n 1.1v 689.755n 0.0v 694.745n 0.0v 694.755n 0.0v 699.745n 0.0v 699.755n 0.0v 704.745n 0.0v 704.755n 0.0v 709.745n 0.0v 709.755n 0.0v 714.745n 0.0v 714.755n 1.1v 719.745n 1.1v 719.755n 1.1v 724.745n 1.1v 724.755n 1.1v 729.745n 1.1v 729.755n 1.1v 734.745n 1.1v 734.755n 1.1v 739.745n 1.1v 739.755n 1.1v 744.745n 1.1v 744.755n 1.1v 749.745n 1.1v 749.755n 1.1v 754.745n 1.1v 754.755n 1.1v 759.745n 1.1v 759.755n 1.1v 764.745n 1.1v 764.755n 1.1v 769.745n 1.1v 769.755n 1.1v 774.745n 1.1v 774.755n 1.1v 779.745n 1.1v 779.755n 1.1v 784.745n 1.1v 784.755n 1.1v 789.745n 1.1v 789.755n 1.1v 794.745n 1.1v 794.755n 1.1v 799.745n 1.1v 799.755n 1.1v 804.745n 1.1v 804.755n 1.1v 809.745n 1.1v 809.755n 1.1v 814.745n 1.1v 814.755n 1.1v 819.745n 1.1v 819.755n 1.1v 824.745n 1.1v 824.755n 1.1v 829.745n 1.1v 829.755n 1.1v 834.745n 1.1v 834.755n 1.1v 839.745n 1.1v 839.755n 0.0v 844.745n 0.0v 844.755n 0.0v 849.745n 0.0v 849.755n 0.0v 854.745n 0.0v 854.755n 0.0v 859.745n 0.0v 859.755n 0.0v 864.745n 0.0v 864.755n 0.0v 869.745n 0.0v 869.755n 1.1v 874.745n 1.1v 874.755n 1.1v 879.745n 1.1v 879.755n 1.1v 884.745n 1.1v 884.755n 1.1v 889.745n 1.1v 889.755n 1.1v 894.745n 1.1v 894.755n 0.0v 899.745n 0.0v 899.755n 0.0v 904.745n 0.0v 904.755n 0.0v 909.745n 0.0v 909.755n 0.0v 914.745n 0.0v 914.755n 0.0v 919.745n 0.0v 919.755n 0.0v 924.745n 0.0v 924.755n 0.0v 929.745n 0.0v 929.755n 0.0v 934.745n 0.0v 934.755n 0.0v 939.745n 0.0v 939.755n 0.0v 944.745n 0.0v 944.755n 0.0v 949.745n 0.0v 949.755n 0.0v 954.745n 0.0v 954.755n 0.0v 959.745n 0.0v 959.755n 0.0v 964.745n 0.0v 964.755n 0.0v 969.745n 0.0v 969.755n 0.0v 974.745n 0.0v 974.755n 0.0v 979.745n 0.0v 979.755n 0.0v 984.745n 0.0v 984.755n 0.0v 989.745n 0.0v 989.755n 0.0v 994.745n 0.0v 994.755n 0.0v 999.745n 0.0v 999.755n 0.0v 1004.745n 0.0v 1004.755n 0.0v 1009.745n 0.0v 1009.755n 0.0v 1014.745n 0.0v 1014.755n 0.0v 1019.745n 0.0v 1019.755n 0.0v 1024.745n 0.0v 1024.755n 0.0v )
* (time, data): [(0, 0), (5, 1), (10, 1), (15, 1), (20, 1), (25, 1), (30, 0), (35, 1), (40, 1), (45, 1), (50, 1), (55, 1), (60, 0), (65, 0), (70, 1), (75, 1), (80, 1), (85, 1), (90, 1), (95, 1), (100, 0), (105, 0), (110, 0), (115, 0), (120, 0), (125, 1), (130, 1), (135, 0), (140, 1), (145, 1), (150, 1), (155, 1), (160, 1), (165, 0), (170, 0), (175, 0), (180, 0), (185, 0), (190, 0), (195, 0), (200, 0), (205, 0), (210, 0), (215, 0), (220, 1), (225, 1), (230, 1), (235, 1), (240, 1), (245, 0), (250, 0), (255, 1), (260, 1), (265, 1), (270, 1), (275, 1), (280, 1), (285, 0), (290, 0), (295, 0), (300, 0), (305, 1), (310, 1), (315, 1), (320, 1), (325, 1), (330, 0), (335, 0), (340, 0), (345, 1), (350, 1), (355, 1), (360, 1), (365, 1), (370, 0), (375, 1), (380, 1), (385, 0), (390, 0), (395, 0), (400, 0), (405, 0), (410, 0), (415, 0), (420, 0), (425, 0), (430, 1), (435, 1), (440, 1), (445, 1), (450, 1), (455, 1), (460, 1), (465, 1), (470, 1), (475, 1), (480, 0), (485, 0), (490, 0), (495, 0), (500, 0), (505, 0), (510, 0), (515, 0), (520, 0), (525, 0), (530, 0), (535, 0), (540, 0), (545, 0), (550, 0), (555, 1), (560, 1), (565, 1), (570, 0), (575, 0), (580, 0), (585, 1), (590, 1), (595, 1), (600, 1), (605, 1), (610, 1), (615, 1), (620, 0), (625, 0), (630, 0), (635, 0), (640, 0), (645, 0), (650, 0), (655, 1), (660, 1), (665, 1), (670, 1), (675, 1), (680, 1), (685, 1), (690, 0), (695, 0), (700, 0), (705, 0), (710, 0), (715, 1), (720, 1), (725, 1), (730, 1), (735, 1), (740, 1), (745, 1), (750, 1), (755, 1), (760, 1), (765, 1), (770, 1), (775, 1), (780, 1), (785, 1), (790, 1), (795, 0), (800, 0), (805, 0), (810, 0), (815, 0), (820, 0), (825, 0), (830, 0), (835, 0), (840, 1), (845, 1), (850, 1), (855, 1), (860, 1), (865, 1), (870, 0), (875, 0), (880, 0), (885, 0), (890, 0), (895, 1), (900, 1), (905, 1), (910, 1), (915, 1), (920, 1), (925, 1), (930, 1), (935, 1), (940, 1), (945, 1), (950, 1), (955, 1), (960, 1), (965, 1), (970, 1), (975, 1), (980, 1), (985, 0), (990, 1), (995, 1), (1000, 1), (1005, 1), (1010, 1), (1015, 0), (1020, 1), (1025, 1)]
Vdin0_29  din0_29  0 PWL (0n 0.0v 4.745n 0.0v 4.755n 1.1v 9.745n 1.1v 9.755n 1.1v 14.745n 1.1v 14.755n 1.1v 19.745n 1.1v 19.755n 1.1v 24.745n 1.1v 24.755n 1.1v 29.745n 1.1v 29.755n 0.0v 34.745n 0.0v 34.755n 1.1v 39.745n 1.1v 39.755n 1.1v 44.745n 1.1v 44.755n 1.1v 49.745n 1.1v 49.755n 1.1v 54.745n 1.1v 54.755n 1.1v 59.745n 1.1v 59.755n 0.0v 64.745n 0.0v 64.755n 0.0v 69.745n 0.0v 69.755n 1.1v 74.745n 1.1v 74.755n 1.1v 79.745n 1.1v 79.755n 1.1v 84.745n 1.1v 84.755n 1.1v 89.745n 1.1v 89.755n 1.1v 94.745n 1.1v 94.755n 1.1v 99.745n 1.1v 99.755n 0.0v 104.745n 0.0v 104.755n 0.0v 109.745n 0.0v 109.755n 0.0v 114.745n 0.0v 114.755n 0.0v 119.745n 0.0v 119.755n 0.0v 124.745n 0.0v 124.755n 1.1v 129.745n 1.1v 129.755n 1.1v 134.745n 1.1v 134.755n 0.0v 139.745n 0.0v 139.755n 1.1v 144.745n 1.1v 144.755n 1.1v 149.745n 1.1v 149.755n 1.1v 154.745n 1.1v 154.755n 1.1v 159.745n 1.1v 159.755n 1.1v 164.745n 1.1v 164.755n 0.0v 169.745n 0.0v 169.755n 0.0v 174.745n 0.0v 174.755n 0.0v 179.745n 0.0v 179.755n 0.0v 184.745n 0.0v 184.755n 0.0v 189.745n 0.0v 189.755n 0.0v 194.745n 0.0v 194.755n 0.0v 199.745n 0.0v 199.755n 0.0v 204.745n 0.0v 204.755n 0.0v 209.745n 0.0v 209.755n 0.0v 214.745n 0.0v 214.755n 0.0v 219.745n 0.0v 219.755n 1.1v 224.745n 1.1v 224.755n 1.1v 229.745n 1.1v 229.755n 1.1v 234.745n 1.1v 234.755n 1.1v 239.745n 1.1v 239.755n 1.1v 244.745n 1.1v 244.755n 0.0v 249.745n 0.0v 249.755n 0.0v 254.745n 0.0v 254.755n 1.1v 259.745n 1.1v 259.755n 1.1v 264.745n 1.1v 264.755n 1.1v 269.745n 1.1v 269.755n 1.1v 274.745n 1.1v 274.755n 1.1v 279.745n 1.1v 279.755n 1.1v 284.745n 1.1v 284.755n 0.0v 289.745n 0.0v 289.755n 0.0v 294.745n 0.0v 294.755n 0.0v 299.745n 0.0v 299.755n 0.0v 304.745n 0.0v 304.755n 1.1v 309.745n 1.1v 309.755n 1.1v 314.745n 1.1v 314.755n 1.1v 319.745n 1.1v 319.755n 1.1v 324.745n 1.1v 324.755n 1.1v 329.745n 1.1v 329.755n 0.0v 334.745n 0.0v 334.755n 0.0v 339.745n 0.0v 339.755n 0.0v 344.745n 0.0v 344.755n 1.1v 349.745n 1.1v 349.755n 1.1v 354.745n 1.1v 354.755n 1.1v 359.745n 1.1v 359.755n 1.1v 364.745n 1.1v 364.755n 1.1v 369.745n 1.1v 369.755n 0.0v 374.745n 0.0v 374.755n 1.1v 379.745n 1.1v 379.755n 1.1v 384.745n 1.1v 384.755n 0.0v 389.745n 0.0v 389.755n 0.0v 394.745n 0.0v 394.755n 0.0v 399.745n 0.0v 399.755n 0.0v 404.745n 0.0v 404.755n 0.0v 409.745n 0.0v 409.755n 0.0v 414.745n 0.0v 414.755n 0.0v 419.745n 0.0v 419.755n 0.0v 424.745n 0.0v 424.755n 0.0v 429.745n 0.0v 429.755n 1.1v 434.745n 1.1v 434.755n 1.1v 439.745n 1.1v 439.755n 1.1v 444.745n 1.1v 444.755n 1.1v 449.745n 1.1v 449.755n 1.1v 454.745n 1.1v 454.755n 1.1v 459.745n 1.1v 459.755n 1.1v 464.745n 1.1v 464.755n 1.1v 469.745n 1.1v 469.755n 1.1v 474.745n 1.1v 474.755n 1.1v 479.745n 1.1v 479.755n 0.0v 484.745n 0.0v 484.755n 0.0v 489.745n 0.0v 489.755n 0.0v 494.745n 0.0v 494.755n 0.0v 499.745n 0.0v 499.755n 0.0v 504.745n 0.0v 504.755n 0.0v 509.745n 0.0v 509.755n 0.0v 514.745n 0.0v 514.755n 0.0v 519.745n 0.0v 519.755n 0.0v 524.745n 0.0v 524.755n 0.0v 529.745n 0.0v 529.755n 0.0v 534.745n 0.0v 534.755n 0.0v 539.745n 0.0v 539.755n 0.0v 544.745n 0.0v 544.755n 0.0v 549.745n 0.0v 549.755n 0.0v 554.745n 0.0v 554.755n 1.1v 559.745n 1.1v 559.755n 1.1v 564.745n 1.1v 564.755n 1.1v 569.745n 1.1v 569.755n 0.0v 574.745n 0.0v 574.755n 0.0v 579.745n 0.0v 579.755n 0.0v 584.745n 0.0v 584.755n 1.1v 589.745n 1.1v 589.755n 1.1v 594.745n 1.1v 594.755n 1.1v 599.745n 1.1v 599.755n 1.1v 604.745n 1.1v 604.755n 1.1v 609.745n 1.1v 609.755n 1.1v 614.745n 1.1v 614.755n 1.1v 619.745n 1.1v 619.755n 0.0v 624.745n 0.0v 624.755n 0.0v 629.745n 0.0v 629.755n 0.0v 634.745n 0.0v 634.755n 0.0v 639.745n 0.0v 639.755n 0.0v 644.745n 0.0v 644.755n 0.0v 649.745n 0.0v 649.755n 0.0v 654.745n 0.0v 654.755n 1.1v 659.745n 1.1v 659.755n 1.1v 664.745n 1.1v 664.755n 1.1v 669.745n 1.1v 669.755n 1.1v 674.745n 1.1v 674.755n 1.1v 679.745n 1.1v 679.755n 1.1v 684.745n 1.1v 684.755n 1.1v 689.745n 1.1v 689.755n 0.0v 694.745n 0.0v 694.755n 0.0v 699.745n 0.0v 699.755n 0.0v 704.745n 0.0v 704.755n 0.0v 709.745n 0.0v 709.755n 0.0v 714.745n 0.0v 714.755n 1.1v 719.745n 1.1v 719.755n 1.1v 724.745n 1.1v 724.755n 1.1v 729.745n 1.1v 729.755n 1.1v 734.745n 1.1v 734.755n 1.1v 739.745n 1.1v 739.755n 1.1v 744.745n 1.1v 744.755n 1.1v 749.745n 1.1v 749.755n 1.1v 754.745n 1.1v 754.755n 1.1v 759.745n 1.1v 759.755n 1.1v 764.745n 1.1v 764.755n 1.1v 769.745n 1.1v 769.755n 1.1v 774.745n 1.1v 774.755n 1.1v 779.745n 1.1v 779.755n 1.1v 784.745n 1.1v 784.755n 1.1v 789.745n 1.1v 789.755n 1.1v 794.745n 1.1v 794.755n 0.0v 799.745n 0.0v 799.755n 0.0v 804.745n 0.0v 804.755n 0.0v 809.745n 0.0v 809.755n 0.0v 814.745n 0.0v 814.755n 0.0v 819.745n 0.0v 819.755n 0.0v 824.745n 0.0v 824.755n 0.0v 829.745n 0.0v 829.755n 0.0v 834.745n 0.0v 834.755n 0.0v 839.745n 0.0v 839.755n 1.1v 844.745n 1.1v 844.755n 1.1v 849.745n 1.1v 849.755n 1.1v 854.745n 1.1v 854.755n 1.1v 859.745n 1.1v 859.755n 1.1v 864.745n 1.1v 864.755n 1.1v 869.745n 1.1v 869.755n 0.0v 874.745n 0.0v 874.755n 0.0v 879.745n 0.0v 879.755n 0.0v 884.745n 0.0v 884.755n 0.0v 889.745n 0.0v 889.755n 0.0v 894.745n 0.0v 894.755n 1.1v 899.745n 1.1v 899.755n 1.1v 904.745n 1.1v 904.755n 1.1v 909.745n 1.1v 909.755n 1.1v 914.745n 1.1v 914.755n 1.1v 919.745n 1.1v 919.755n 1.1v 924.745n 1.1v 924.755n 1.1v 929.745n 1.1v 929.755n 1.1v 934.745n 1.1v 934.755n 1.1v 939.745n 1.1v 939.755n 1.1v 944.745n 1.1v 944.755n 1.1v 949.745n 1.1v 949.755n 1.1v 954.745n 1.1v 954.755n 1.1v 959.745n 1.1v 959.755n 1.1v 964.745n 1.1v 964.755n 1.1v 969.745n 1.1v 969.755n 1.1v 974.745n 1.1v 974.755n 1.1v 979.745n 1.1v 979.755n 1.1v 984.745n 1.1v 984.755n 0.0v 989.745n 0.0v 989.755n 1.1v 994.745n 1.1v 994.755n 1.1v 999.745n 1.1v 999.755n 1.1v 1004.745n 1.1v 1004.755n 1.1v 1009.745n 1.1v 1009.755n 1.1v 1014.745n 1.1v 1014.755n 0.0v 1019.745n 0.0v 1019.755n 1.1v 1024.745n 1.1v 1024.755n 1.1v )
* (time, data): [(0, 0), (5, 0), (10, 0), (15, 0), (20, 0), (25, 0), (30, 0), (35, 1), (40, 1), (45, 1), (50, 1), (55, 1), (60, 1), (65, 1), (70, 0), (75, 0), (80, 0), (85, 0), (90, 0), (95, 0), (100, 1), (105, 1), (110, 1), (115, 1), (120, 1), (125, 0), (130, 0), (135, 1), (140, 0), (145, 1), (150, 1), (155, 1), (160, 1), (165, 1), (170, 1), (175, 1), (180, 1), (185, 1), (190, 1), (195, 1), (200, 0), (205, 0), (210, 0), (215, 0), (220, 1), (225, 1), (230, 0), (235, 0), (240, 0), (245, 1), (250, 1), (255, 1), (260, 1), (265, 1), (270, 0), (275, 0), (280, 0), (285, 0), (290, 0), (295, 0), (300, 0), (305, 0), (310, 0), (315, 0), (320, 0), (325, 1), (330, 1), (335, 1), (340, 1), (345, 1), (350, 1), (355, 1), (360, 1), (365, 1), (370, 1), (375, 1), (380, 1), (385, 0), (390, 0), (395, 0), (400, 0), (405, 0), (410, 0), (415, 1), (420, 1), (425, 1), (430, 0), (435, 0), (440, 0), (445, 0), (450, 0), (455, 0), (460, 0), (465, 0), (470, 0), (475, 0), (480, 0), (485, 1), (490, 1), (495, 0), (500, 0), (505, 0), (510, 0), (515, 0), (520, 1), (525, 1), (530, 1), (535, 0), (540, 1), (545, 1), (550, 1), (555, 1), (560, 1), (565, 1), (570, 0), (575, 0), (580, 0), (585, 1), (590, 1), (595, 1), (600, 1), (605, 1), (610, 1), (615, 1), (620, 0), (625, 0), (630, 0), (635, 0), (640, 0), (645, 0), (650, 0), (655, 0), (660, 0), (665, 0), (670, 0), (675, 0), (680, 0), (685, 0), (690, 1), (695, 1), (700, 1), (705, 1), (710, 1), (715, 0), (720, 0), (725, 0), (730, 0), (735, 0), (740, 0), (745, 0), (750, 0), (755, 0), (760, 0), (765, 0), (770, 0), (775, 0), (780, 0), (785, 0), (790, 0), (795, 1), (800, 1), (805, 1), (810, 1), (815, 1), (820, 1), (825, 1), (830, 1), (835, 1), (840, 1), (845, 1), (850, 1), (855, 1), (860, 1), (865, 1), (870, 1), (875, 1), (880, 1), (885, 1), (890, 1), (895, 0), (900, 0), (905, 0), (910, 0), (915, 0), (920, 0), (925, 0), (930, 0), (935, 0), (940, 1), (945, 1), (950, 1), (955, 1), (960, 1), (965, 1), (970, 1), (975, 1), (980, 1), (985, 0), (990, 1), (995, 1), (1000, 1), (1005, 1), (1010, 1), (1015, 1), (1020, 0), (1025, 0)]
Vdin0_30  din0_30  0 PWL (0n 0.0v 4.745n 0.0v 4.755n 0.0v 9.745n 0.0v 9.755n 0.0v 14.745n 0.0v 14.755n 0.0v 19.745n 0.0v 19.755n 0.0v 24.745n 0.0v 24.755n 0.0v 29.745n 0.0v 29.755n 0.0v 34.745n 0.0v 34.755n 1.1v 39.745n 1.1v 39.755n 1.1v 44.745n 1.1v 44.755n 1.1v 49.745n 1.1v 49.755n 1.1v 54.745n 1.1v 54.755n 1.1v 59.745n 1.1v 59.755n 1.1v 64.745n 1.1v 64.755n 1.1v 69.745n 1.1v 69.755n 0.0v 74.745n 0.0v 74.755n 0.0v 79.745n 0.0v 79.755n 0.0v 84.745n 0.0v 84.755n 0.0v 89.745n 0.0v 89.755n 0.0v 94.745n 0.0v 94.755n 0.0v 99.745n 0.0v 99.755n 1.1v 104.745n 1.1v 104.755n 1.1v 109.745n 1.1v 109.755n 1.1v 114.745n 1.1v 114.755n 1.1v 119.745n 1.1v 119.755n 1.1v 124.745n 1.1v 124.755n 0.0v 129.745n 0.0v 129.755n 0.0v 134.745n 0.0v 134.755n 1.1v 139.745n 1.1v 139.755n 0.0v 144.745n 0.0v 144.755n 1.1v 149.745n 1.1v 149.755n 1.1v 154.745n 1.1v 154.755n 1.1v 159.745n 1.1v 159.755n 1.1v 164.745n 1.1v 164.755n 1.1v 169.745n 1.1v 169.755n 1.1v 174.745n 1.1v 174.755n 1.1v 179.745n 1.1v 179.755n 1.1v 184.745n 1.1v 184.755n 1.1v 189.745n 1.1v 189.755n 1.1v 194.745n 1.1v 194.755n 1.1v 199.745n 1.1v 199.755n 0.0v 204.745n 0.0v 204.755n 0.0v 209.745n 0.0v 209.755n 0.0v 214.745n 0.0v 214.755n 0.0v 219.745n 0.0v 219.755n 1.1v 224.745n 1.1v 224.755n 1.1v 229.745n 1.1v 229.755n 0.0v 234.745n 0.0v 234.755n 0.0v 239.745n 0.0v 239.755n 0.0v 244.745n 0.0v 244.755n 1.1v 249.745n 1.1v 249.755n 1.1v 254.745n 1.1v 254.755n 1.1v 259.745n 1.1v 259.755n 1.1v 264.745n 1.1v 264.755n 1.1v 269.745n 1.1v 269.755n 0.0v 274.745n 0.0v 274.755n 0.0v 279.745n 0.0v 279.755n 0.0v 284.745n 0.0v 284.755n 0.0v 289.745n 0.0v 289.755n 0.0v 294.745n 0.0v 294.755n 0.0v 299.745n 0.0v 299.755n 0.0v 304.745n 0.0v 304.755n 0.0v 309.745n 0.0v 309.755n 0.0v 314.745n 0.0v 314.755n 0.0v 319.745n 0.0v 319.755n 0.0v 324.745n 0.0v 324.755n 1.1v 329.745n 1.1v 329.755n 1.1v 334.745n 1.1v 334.755n 1.1v 339.745n 1.1v 339.755n 1.1v 344.745n 1.1v 344.755n 1.1v 349.745n 1.1v 349.755n 1.1v 354.745n 1.1v 354.755n 1.1v 359.745n 1.1v 359.755n 1.1v 364.745n 1.1v 364.755n 1.1v 369.745n 1.1v 369.755n 1.1v 374.745n 1.1v 374.755n 1.1v 379.745n 1.1v 379.755n 1.1v 384.745n 1.1v 384.755n 0.0v 389.745n 0.0v 389.755n 0.0v 394.745n 0.0v 394.755n 0.0v 399.745n 0.0v 399.755n 0.0v 404.745n 0.0v 404.755n 0.0v 409.745n 0.0v 409.755n 0.0v 414.745n 0.0v 414.755n 1.1v 419.745n 1.1v 419.755n 1.1v 424.745n 1.1v 424.755n 1.1v 429.745n 1.1v 429.755n 0.0v 434.745n 0.0v 434.755n 0.0v 439.745n 0.0v 439.755n 0.0v 444.745n 0.0v 444.755n 0.0v 449.745n 0.0v 449.755n 0.0v 454.745n 0.0v 454.755n 0.0v 459.745n 0.0v 459.755n 0.0v 464.745n 0.0v 464.755n 0.0v 469.745n 0.0v 469.755n 0.0v 474.745n 0.0v 474.755n 0.0v 479.745n 0.0v 479.755n 0.0v 484.745n 0.0v 484.755n 1.1v 489.745n 1.1v 489.755n 1.1v 494.745n 1.1v 494.755n 0.0v 499.745n 0.0v 499.755n 0.0v 504.745n 0.0v 504.755n 0.0v 509.745n 0.0v 509.755n 0.0v 514.745n 0.0v 514.755n 0.0v 519.745n 0.0v 519.755n 1.1v 524.745n 1.1v 524.755n 1.1v 529.745n 1.1v 529.755n 1.1v 534.745n 1.1v 534.755n 0.0v 539.745n 0.0v 539.755n 1.1v 544.745n 1.1v 544.755n 1.1v 549.745n 1.1v 549.755n 1.1v 554.745n 1.1v 554.755n 1.1v 559.745n 1.1v 559.755n 1.1v 564.745n 1.1v 564.755n 1.1v 569.745n 1.1v 569.755n 0.0v 574.745n 0.0v 574.755n 0.0v 579.745n 0.0v 579.755n 0.0v 584.745n 0.0v 584.755n 1.1v 589.745n 1.1v 589.755n 1.1v 594.745n 1.1v 594.755n 1.1v 599.745n 1.1v 599.755n 1.1v 604.745n 1.1v 604.755n 1.1v 609.745n 1.1v 609.755n 1.1v 614.745n 1.1v 614.755n 1.1v 619.745n 1.1v 619.755n 0.0v 624.745n 0.0v 624.755n 0.0v 629.745n 0.0v 629.755n 0.0v 634.745n 0.0v 634.755n 0.0v 639.745n 0.0v 639.755n 0.0v 644.745n 0.0v 644.755n 0.0v 649.745n 0.0v 649.755n 0.0v 654.745n 0.0v 654.755n 0.0v 659.745n 0.0v 659.755n 0.0v 664.745n 0.0v 664.755n 0.0v 669.745n 0.0v 669.755n 0.0v 674.745n 0.0v 674.755n 0.0v 679.745n 0.0v 679.755n 0.0v 684.745n 0.0v 684.755n 0.0v 689.745n 0.0v 689.755n 1.1v 694.745n 1.1v 694.755n 1.1v 699.745n 1.1v 699.755n 1.1v 704.745n 1.1v 704.755n 1.1v 709.745n 1.1v 709.755n 1.1v 714.745n 1.1v 714.755n 0.0v 719.745n 0.0v 719.755n 0.0v 724.745n 0.0v 724.755n 0.0v 729.745n 0.0v 729.755n 0.0v 734.745n 0.0v 734.755n 0.0v 739.745n 0.0v 739.755n 0.0v 744.745n 0.0v 744.755n 0.0v 749.745n 0.0v 749.755n 0.0v 754.745n 0.0v 754.755n 0.0v 759.745n 0.0v 759.755n 0.0v 764.745n 0.0v 764.755n 0.0v 769.745n 0.0v 769.755n 0.0v 774.745n 0.0v 774.755n 0.0v 779.745n 0.0v 779.755n 0.0v 784.745n 0.0v 784.755n 0.0v 789.745n 0.0v 789.755n 0.0v 794.745n 0.0v 794.755n 1.1v 799.745n 1.1v 799.755n 1.1v 804.745n 1.1v 804.755n 1.1v 809.745n 1.1v 809.755n 1.1v 814.745n 1.1v 814.755n 1.1v 819.745n 1.1v 819.755n 1.1v 824.745n 1.1v 824.755n 1.1v 829.745n 1.1v 829.755n 1.1v 834.745n 1.1v 834.755n 1.1v 839.745n 1.1v 839.755n 1.1v 844.745n 1.1v 844.755n 1.1v 849.745n 1.1v 849.755n 1.1v 854.745n 1.1v 854.755n 1.1v 859.745n 1.1v 859.755n 1.1v 864.745n 1.1v 864.755n 1.1v 869.745n 1.1v 869.755n 1.1v 874.745n 1.1v 874.755n 1.1v 879.745n 1.1v 879.755n 1.1v 884.745n 1.1v 884.755n 1.1v 889.745n 1.1v 889.755n 1.1v 894.745n 1.1v 894.755n 0.0v 899.745n 0.0v 899.755n 0.0v 904.745n 0.0v 904.755n 0.0v 909.745n 0.0v 909.755n 0.0v 914.745n 0.0v 914.755n 0.0v 919.745n 0.0v 919.755n 0.0v 924.745n 0.0v 924.755n 0.0v 929.745n 0.0v 929.755n 0.0v 934.745n 0.0v 934.755n 0.0v 939.745n 0.0v 939.755n 1.1v 944.745n 1.1v 944.755n 1.1v 949.745n 1.1v 949.755n 1.1v 954.745n 1.1v 954.755n 1.1v 959.745n 1.1v 959.755n 1.1v 964.745n 1.1v 964.755n 1.1v 969.745n 1.1v 969.755n 1.1v 974.745n 1.1v 974.755n 1.1v 979.745n 1.1v 979.755n 1.1v 984.745n 1.1v 984.755n 0.0v 989.745n 0.0v 989.755n 1.1v 994.745n 1.1v 994.755n 1.1v 999.745n 1.1v 999.755n 1.1v 1004.745n 1.1v 1004.755n 1.1v 1009.745n 1.1v 1009.755n 1.1v 1014.745n 1.1v 1014.755n 1.1v 1019.745n 1.1v 1019.755n 0.0v 1024.745n 0.0v 1024.755n 0.0v )
* (time, data): [(0, 0), (5, 0), (10, 1), (15, 0), (20, 0), (25, 0), (30, 0), (35, 1), (40, 1), (45, 1), (50, 1), (55, 1), (60, 1), (65, 1), (70, 1), (75, 1), (80, 1), (85, 1), (90, 1), (95, 1), (100, 1), (105, 1), (110, 1), (115, 0), (120, 0), (125, 1), (130, 1), (135, 0), (140, 1), (145, 0), (150, 0), (155, 0), (160, 0), (165, 1), (170, 1), (175, 1), (180, 1), (185, 1), (190, 1), (195, 1), (200, 0), (205, 0), (210, 0), (215, 0), (220, 1), (225, 1), (230, 0), (235, 0), (240, 0), (245, 0), (250, 0), (255, 1), (260, 1), (265, 1), (270, 1), (275, 1), (280, 1), (285, 1), (290, 1), (295, 1), (300, 1), (305, 1), (310, 1), (315, 1), (320, 1), (325, 0), (330, 1), (335, 1), (340, 1), (345, 0), (350, 0), (355, 0), (360, 0), (365, 0), (370, 1), (375, 0), (380, 0), (385, 0), (390, 0), (395, 0), (400, 0), (405, 0), (410, 0), (415, 1), (420, 1), (425, 1), (430, 0), (435, 0), (440, 0), (445, 0), (450, 0), (455, 0), (460, 0), (465, 0), (470, 0), (475, 0), (480, 1), (485, 1), (490, 1), (495, 0), (500, 0), (505, 0), (510, 0), (515, 0), (520, 1), (525, 1), (530, 1), (535, 0), (540, 1), (545, 1), (550, 1), (555, 1), (560, 1), (565, 1), (570, 0), (575, 0), (580, 0), (585, 0), (590, 0), (595, 0), (600, 0), (605, 0), (610, 0), (615, 0), (620, 0), (625, 0), (630, 0), (635, 0), (640, 0), (645, 0), (650, 1), (655, 0), (660, 0), (665, 0), (670, 0), (675, 0), (680, 0), (685, 0), (690, 0), (695, 0), (700, 0), (705, 0), (710, 0), (715, 0), (720, 0), (725, 1), (730, 1), (735, 1), (740, 1), (745, 1), (750, 1), (755, 1), (760, 1), (765, 1), (770, 1), (775, 1), (780, 1), (785, 1), (790, 1), (795, 1), (800, 1), (805, 1), (810, 1), (815, 1), (820, 1), (825, 1), (830, 1), (835, 1), (840, 1), (845, 1), (850, 1), (855, 1), (860, 1), (865, 1), (870, 0), (875, 0), (880, 0), (885, 0), (890, 0), (895, 0), (900, 0), (905, 0), (910, 0), (915, 0), (920, 1), (925, 1), (930, 1), (935, 1), (940, 0), (945, 0), (950, 0), (955, 0), (960, 0), (965, 0), (970, 0), (975, 0), (980, 0), (985, 0), (990, 1), (995, 1), (1000, 1), (1005, 1), (1010, 1), (1015, 0), (1020, 0), (1025, 0)]
Vdin0_31  din0_31  0 PWL (0n 0.0v 4.745n 0.0v 4.755n 0.0v 9.745n 0.0v 9.755n 1.1v 14.745n 1.1v 14.755n 0.0v 19.745n 0.0v 19.755n 0.0v 24.745n 0.0v 24.755n 0.0v 29.745n 0.0v 29.755n 0.0v 34.745n 0.0v 34.755n 1.1v 39.745n 1.1v 39.755n 1.1v 44.745n 1.1v 44.755n 1.1v 49.745n 1.1v 49.755n 1.1v 54.745n 1.1v 54.755n 1.1v 59.745n 1.1v 59.755n 1.1v 64.745n 1.1v 64.755n 1.1v 69.745n 1.1v 69.755n 1.1v 74.745n 1.1v 74.755n 1.1v 79.745n 1.1v 79.755n 1.1v 84.745n 1.1v 84.755n 1.1v 89.745n 1.1v 89.755n 1.1v 94.745n 1.1v 94.755n 1.1v 99.745n 1.1v 99.755n 1.1v 104.745n 1.1v 104.755n 1.1v 109.745n 1.1v 109.755n 1.1v 114.745n 1.1v 114.755n 0.0v 119.745n 0.0v 119.755n 0.0v 124.745n 0.0v 124.755n 1.1v 129.745n 1.1v 129.755n 1.1v 134.745n 1.1v 134.755n 0.0v 139.745n 0.0v 139.755n 1.1v 144.745n 1.1v 144.755n 0.0v 149.745n 0.0v 149.755n 0.0v 154.745n 0.0v 154.755n 0.0v 159.745n 0.0v 159.755n 0.0v 164.745n 0.0v 164.755n 1.1v 169.745n 1.1v 169.755n 1.1v 174.745n 1.1v 174.755n 1.1v 179.745n 1.1v 179.755n 1.1v 184.745n 1.1v 184.755n 1.1v 189.745n 1.1v 189.755n 1.1v 194.745n 1.1v 194.755n 1.1v 199.745n 1.1v 199.755n 0.0v 204.745n 0.0v 204.755n 0.0v 209.745n 0.0v 209.755n 0.0v 214.745n 0.0v 214.755n 0.0v 219.745n 0.0v 219.755n 1.1v 224.745n 1.1v 224.755n 1.1v 229.745n 1.1v 229.755n 0.0v 234.745n 0.0v 234.755n 0.0v 239.745n 0.0v 239.755n 0.0v 244.745n 0.0v 244.755n 0.0v 249.745n 0.0v 249.755n 0.0v 254.745n 0.0v 254.755n 1.1v 259.745n 1.1v 259.755n 1.1v 264.745n 1.1v 264.755n 1.1v 269.745n 1.1v 269.755n 1.1v 274.745n 1.1v 274.755n 1.1v 279.745n 1.1v 279.755n 1.1v 284.745n 1.1v 284.755n 1.1v 289.745n 1.1v 289.755n 1.1v 294.745n 1.1v 294.755n 1.1v 299.745n 1.1v 299.755n 1.1v 304.745n 1.1v 304.755n 1.1v 309.745n 1.1v 309.755n 1.1v 314.745n 1.1v 314.755n 1.1v 319.745n 1.1v 319.755n 1.1v 324.745n 1.1v 324.755n 0.0v 329.745n 0.0v 329.755n 1.1v 334.745n 1.1v 334.755n 1.1v 339.745n 1.1v 339.755n 1.1v 344.745n 1.1v 344.755n 0.0v 349.745n 0.0v 349.755n 0.0v 354.745n 0.0v 354.755n 0.0v 359.745n 0.0v 359.755n 0.0v 364.745n 0.0v 364.755n 0.0v 369.745n 0.0v 369.755n 1.1v 374.745n 1.1v 374.755n 0.0v 379.745n 0.0v 379.755n 0.0v 384.745n 0.0v 384.755n 0.0v 389.745n 0.0v 389.755n 0.0v 394.745n 0.0v 394.755n 0.0v 399.745n 0.0v 399.755n 0.0v 404.745n 0.0v 404.755n 0.0v 409.745n 0.0v 409.755n 0.0v 414.745n 0.0v 414.755n 1.1v 419.745n 1.1v 419.755n 1.1v 424.745n 1.1v 424.755n 1.1v 429.745n 1.1v 429.755n 0.0v 434.745n 0.0v 434.755n 0.0v 439.745n 0.0v 439.755n 0.0v 444.745n 0.0v 444.755n 0.0v 449.745n 0.0v 449.755n 0.0v 454.745n 0.0v 454.755n 0.0v 459.745n 0.0v 459.755n 0.0v 464.745n 0.0v 464.755n 0.0v 469.745n 0.0v 469.755n 0.0v 474.745n 0.0v 474.755n 0.0v 479.745n 0.0v 479.755n 1.1v 484.745n 1.1v 484.755n 1.1v 489.745n 1.1v 489.755n 1.1v 494.745n 1.1v 494.755n 0.0v 499.745n 0.0v 499.755n 0.0v 504.745n 0.0v 504.755n 0.0v 509.745n 0.0v 509.755n 0.0v 514.745n 0.0v 514.755n 0.0v 519.745n 0.0v 519.755n 1.1v 524.745n 1.1v 524.755n 1.1v 529.745n 1.1v 529.755n 1.1v 534.745n 1.1v 534.755n 0.0v 539.745n 0.0v 539.755n 1.1v 544.745n 1.1v 544.755n 1.1v 549.745n 1.1v 549.755n 1.1v 554.745n 1.1v 554.755n 1.1v 559.745n 1.1v 559.755n 1.1v 564.745n 1.1v 564.755n 1.1v 569.745n 1.1v 569.755n 0.0v 574.745n 0.0v 574.755n 0.0v 579.745n 0.0v 579.755n 0.0v 584.745n 0.0v 584.755n 0.0v 589.745n 0.0v 589.755n 0.0v 594.745n 0.0v 594.755n 0.0v 599.745n 0.0v 599.755n 0.0v 604.745n 0.0v 604.755n 0.0v 609.745n 0.0v 609.755n 0.0v 614.745n 0.0v 614.755n 0.0v 619.745n 0.0v 619.755n 0.0v 624.745n 0.0v 624.755n 0.0v 629.745n 0.0v 629.755n 0.0v 634.745n 0.0v 634.755n 0.0v 639.745n 0.0v 639.755n 0.0v 644.745n 0.0v 644.755n 0.0v 649.745n 0.0v 649.755n 1.1v 654.745n 1.1v 654.755n 0.0v 659.745n 0.0v 659.755n 0.0v 664.745n 0.0v 664.755n 0.0v 669.745n 0.0v 669.755n 0.0v 674.745n 0.0v 674.755n 0.0v 679.745n 0.0v 679.755n 0.0v 684.745n 0.0v 684.755n 0.0v 689.745n 0.0v 689.755n 0.0v 694.745n 0.0v 694.755n 0.0v 699.745n 0.0v 699.755n 0.0v 704.745n 0.0v 704.755n 0.0v 709.745n 0.0v 709.755n 0.0v 714.745n 0.0v 714.755n 0.0v 719.745n 0.0v 719.755n 0.0v 724.745n 0.0v 724.755n 1.1v 729.745n 1.1v 729.755n 1.1v 734.745n 1.1v 734.755n 1.1v 739.745n 1.1v 739.755n 1.1v 744.745n 1.1v 744.755n 1.1v 749.745n 1.1v 749.755n 1.1v 754.745n 1.1v 754.755n 1.1v 759.745n 1.1v 759.755n 1.1v 764.745n 1.1v 764.755n 1.1v 769.745n 1.1v 769.755n 1.1v 774.745n 1.1v 774.755n 1.1v 779.745n 1.1v 779.755n 1.1v 784.745n 1.1v 784.755n 1.1v 789.745n 1.1v 789.755n 1.1v 794.745n 1.1v 794.755n 1.1v 799.745n 1.1v 799.755n 1.1v 804.745n 1.1v 804.755n 1.1v 809.745n 1.1v 809.755n 1.1v 814.745n 1.1v 814.755n 1.1v 819.745n 1.1v 819.755n 1.1v 824.745n 1.1v 824.755n 1.1v 829.745n 1.1v 829.755n 1.1v 834.745n 1.1v 834.755n 1.1v 839.745n 1.1v 839.755n 1.1v 844.745n 1.1v 844.755n 1.1v 849.745n 1.1v 849.755n 1.1v 854.745n 1.1v 854.755n 1.1v 859.745n 1.1v 859.755n 1.1v 864.745n 1.1v 864.755n 1.1v 869.745n 1.1v 869.755n 0.0v 874.745n 0.0v 874.755n 0.0v 879.745n 0.0v 879.755n 0.0v 884.745n 0.0v 884.755n 0.0v 889.745n 0.0v 889.755n 0.0v 894.745n 0.0v 894.755n 0.0v 899.745n 0.0v 899.755n 0.0v 904.745n 0.0v 904.755n 0.0v 909.745n 0.0v 909.755n 0.0v 914.745n 0.0v 914.755n 0.0v 919.745n 0.0v 919.755n 1.1v 924.745n 1.1v 924.755n 1.1v 929.745n 1.1v 929.755n 1.1v 934.745n 1.1v 934.755n 1.1v 939.745n 1.1v 939.755n 0.0v 944.745n 0.0v 944.755n 0.0v 949.745n 0.0v 949.755n 0.0v 954.745n 0.0v 954.755n 0.0v 959.745n 0.0v 959.755n 0.0v 964.745n 0.0v 964.755n 0.0v 969.745n 0.0v 969.755n 0.0v 974.745n 0.0v 974.755n 0.0v 979.745n 0.0v 979.755n 0.0v 984.745n 0.0v 984.755n 0.0v 989.745n 0.0v 989.755n 1.1v 994.745n 1.1v 994.755n 1.1v 999.745n 1.1v 999.755n 1.1v 1004.745n 1.1v 1004.755n 1.1v 1009.745n 1.1v 1009.755n 1.1v 1014.745n 1.1v 1014.755n 0.0v 1019.745n 0.0v 1019.755n 0.0v 1024.745n 0.0v 1024.755n 0.0v )
* (time, data): [(0, 0), (5, 0), (10, 0), (15, 0), (20, 0), (25, 0), (30, 0), (35, 1), (40, 1), (45, 1), (50, 0), (55, 0), (60, 0), (65, 1), (70, 1), (75, 1), (80, 1), (85, 1), (90, 0), (95, 0), (100, 0), (105, 0), (110, 1), (115, 0), (120, 0), (125, 1), (130, 0), (135, 1), (140, 1), (145, 0), (150, 0), (155, 0), (160, 0), (165, 1), (170, 1), (175, 0), (180, 0), (185, 1), (190, 1), (195, 1), (200, 1), (205, 1), (210, 1), (215, 1), (220, 1), (225, 1), (230, 0), (235, 0), (240, 0), (245, 1), (250, 1), (255, 0), (260, 0), (265, 1), (270, 1), (275, 1), (280, 1), (285, 0), (290, 1), (295, 0), (300, 0), (305, 0), (310, 0), (315, 0), (320, 0), (325, 0), (330, 0), (335, 0), (340, 0), (345, 1), (350, 1), (355, 1), (360, 1), (365, 1), (370, 0), (375, 1), (380, 1), (385, 0), (390, 0), (395, 0), (400, 0), (405, 0), (410, 1), (415, 1), (420, 0), (425, 0), (430, 1), (435, 0), (440, 0), (445, 1), (450, 0), (455, 0), (460, 0), (465, 1), (470, 0), (475, 1), (480, 0), (485, 0), (490, 0), (495, 1), (500, 1), (505, 1), (510, 0), (515, 0), (520, 0), (525, 0), (530, 0), (535, 0), (540, 0), (545, 0), (550, 0), (555, 0), (560, 1), (565, 0), (570, 1), (575, 1), (580, 1), (585, 1), (590, 1), (595, 1), (600, 0), (605, 0), (610, 0), (615, 0), (620, 0), (625, 0), (630, 1), (635, 0), (640, 1), (645, 0), (650, 0), (655, 0), (660, 0), (665, 0), (670, 0), (675, 0), (680, 0), (685, 1), (690, 0), (695, 1), (700, 1), (705, 1), (710, 1), (715, 1), (720, 1), (725, 0), (730, 1), (735, 1), (740, 1), (745, 1), (750, 0), (755, 1), (760, 0), (765, 1), (770, 1), (775, 1), (780, 1), (785, 0), (790, 0), (795, 0), (800, 0), (805, 0), (810, 0), (815, 1), (820, 1), (825, 1), (830, 0), (835, 1), (840, 0), (845, 0), (850, 0), (855, 1), (860, 0), (865, 1), (870, 0), (875, 0), (880, 1), (885, 1), (890, 1), (895, 1), (900, 1), (905, 1), (910, 0), (915, 0), (920, 0), (925, 1), (930, 0), (935, 0), (940, 0), (945, 0), (950, 0), (955, 0), (960, 0), (965, 0), (970, 1), (975, 1), (980, 0), (985, 1), (990, 1), (995, 0), (1000, 0), (1005, 1), (1010, 1), (1015, 1), (1020, 0), (1025, 0)]
Va0_0  a0_0  0 PWL (0n 0.0v 4.745n 0.0v 4.755n 0.0v 9.745n 0.0v 9.755n 0.0v 14.745n 0.0v 14.755n 0.0v 19.745n 0.0v 19.755n 0.0v 24.745n 0.0v 24.755n 0.0v 29.745n 0.0v 29.755n 0.0v 34.745n 0.0v 34.755n 1.1v 39.745n 1.1v 39.755n 1.1v 44.745n 1.1v 44.755n 1.1v 49.745n 1.1v 49.755n 0.0v 54.745n 0.0v 54.755n 0.0v 59.745n 0.0v 59.755n 0.0v 64.745n 0.0v 64.755n 1.1v 69.745n 1.1v 69.755n 1.1v 74.745n 1.1v 74.755n 1.1v 79.745n 1.1v 79.755n 1.1v 84.745n 1.1v 84.755n 1.1v 89.745n 1.1v 89.755n 0.0v 94.745n 0.0v 94.755n 0.0v 99.745n 0.0v 99.755n 0.0v 104.745n 0.0v 104.755n 0.0v 109.745n 0.0v 109.755n 1.1v 114.745n 1.1v 114.755n 0.0v 119.745n 0.0v 119.755n 0.0v 124.745n 0.0v 124.755n 1.1v 129.745n 1.1v 129.755n 0.0v 134.745n 0.0v 134.755n 1.1v 139.745n 1.1v 139.755n 1.1v 144.745n 1.1v 144.755n 0.0v 149.745n 0.0v 149.755n 0.0v 154.745n 0.0v 154.755n 0.0v 159.745n 0.0v 159.755n 0.0v 164.745n 0.0v 164.755n 1.1v 169.745n 1.1v 169.755n 1.1v 174.745n 1.1v 174.755n 0.0v 179.745n 0.0v 179.755n 0.0v 184.745n 0.0v 184.755n 1.1v 189.745n 1.1v 189.755n 1.1v 194.745n 1.1v 194.755n 1.1v 199.745n 1.1v 199.755n 1.1v 204.745n 1.1v 204.755n 1.1v 209.745n 1.1v 209.755n 1.1v 214.745n 1.1v 214.755n 1.1v 219.745n 1.1v 219.755n 1.1v 224.745n 1.1v 224.755n 1.1v 229.745n 1.1v 229.755n 0.0v 234.745n 0.0v 234.755n 0.0v 239.745n 0.0v 239.755n 0.0v 244.745n 0.0v 244.755n 1.1v 249.745n 1.1v 249.755n 1.1v 254.745n 1.1v 254.755n 0.0v 259.745n 0.0v 259.755n 0.0v 264.745n 0.0v 264.755n 1.1v 269.745n 1.1v 269.755n 1.1v 274.745n 1.1v 274.755n 1.1v 279.745n 1.1v 279.755n 1.1v 284.745n 1.1v 284.755n 0.0v 289.745n 0.0v 289.755n 1.1v 294.745n 1.1v 294.755n 0.0v 299.745n 0.0v 299.755n 0.0v 304.745n 0.0v 304.755n 0.0v 309.745n 0.0v 309.755n 0.0v 314.745n 0.0v 314.755n 0.0v 319.745n 0.0v 319.755n 0.0v 324.745n 0.0v 324.755n 0.0v 329.745n 0.0v 329.755n 0.0v 334.745n 0.0v 334.755n 0.0v 339.745n 0.0v 339.755n 0.0v 344.745n 0.0v 344.755n 1.1v 349.745n 1.1v 349.755n 1.1v 354.745n 1.1v 354.755n 1.1v 359.745n 1.1v 359.755n 1.1v 364.745n 1.1v 364.755n 1.1v 369.745n 1.1v 369.755n 0.0v 374.745n 0.0v 374.755n 1.1v 379.745n 1.1v 379.755n 1.1v 384.745n 1.1v 384.755n 0.0v 389.745n 0.0v 389.755n 0.0v 394.745n 0.0v 394.755n 0.0v 399.745n 0.0v 399.755n 0.0v 404.745n 0.0v 404.755n 0.0v 409.745n 0.0v 409.755n 1.1v 414.745n 1.1v 414.755n 1.1v 419.745n 1.1v 419.755n 0.0v 424.745n 0.0v 424.755n 0.0v 429.745n 0.0v 429.755n 1.1v 434.745n 1.1v 434.755n 0.0v 439.745n 0.0v 439.755n 0.0v 444.745n 0.0v 444.755n 1.1v 449.745n 1.1v 449.755n 0.0v 454.745n 0.0v 454.755n 0.0v 459.745n 0.0v 459.755n 0.0v 464.745n 0.0v 464.755n 1.1v 469.745n 1.1v 469.755n 0.0v 474.745n 0.0v 474.755n 1.1v 479.745n 1.1v 479.755n 0.0v 484.745n 0.0v 484.755n 0.0v 489.745n 0.0v 489.755n 0.0v 494.745n 0.0v 494.755n 1.1v 499.745n 1.1v 499.755n 1.1v 504.745n 1.1v 504.755n 1.1v 509.745n 1.1v 509.755n 0.0v 514.745n 0.0v 514.755n 0.0v 519.745n 0.0v 519.755n 0.0v 524.745n 0.0v 524.755n 0.0v 529.745n 0.0v 529.755n 0.0v 534.745n 0.0v 534.755n 0.0v 539.745n 0.0v 539.755n 0.0v 544.745n 0.0v 544.755n 0.0v 549.745n 0.0v 549.755n 0.0v 554.745n 0.0v 554.755n 0.0v 559.745n 0.0v 559.755n 1.1v 564.745n 1.1v 564.755n 0.0v 569.745n 0.0v 569.755n 1.1v 574.745n 1.1v 574.755n 1.1v 579.745n 1.1v 579.755n 1.1v 584.745n 1.1v 584.755n 1.1v 589.745n 1.1v 589.755n 1.1v 594.745n 1.1v 594.755n 1.1v 599.745n 1.1v 599.755n 0.0v 604.745n 0.0v 604.755n 0.0v 609.745n 0.0v 609.755n 0.0v 614.745n 0.0v 614.755n 0.0v 619.745n 0.0v 619.755n 0.0v 624.745n 0.0v 624.755n 0.0v 629.745n 0.0v 629.755n 1.1v 634.745n 1.1v 634.755n 0.0v 639.745n 0.0v 639.755n 1.1v 644.745n 1.1v 644.755n 0.0v 649.745n 0.0v 649.755n 0.0v 654.745n 0.0v 654.755n 0.0v 659.745n 0.0v 659.755n 0.0v 664.745n 0.0v 664.755n 0.0v 669.745n 0.0v 669.755n 0.0v 674.745n 0.0v 674.755n 0.0v 679.745n 0.0v 679.755n 0.0v 684.745n 0.0v 684.755n 1.1v 689.745n 1.1v 689.755n 0.0v 694.745n 0.0v 694.755n 1.1v 699.745n 1.1v 699.755n 1.1v 704.745n 1.1v 704.755n 1.1v 709.745n 1.1v 709.755n 1.1v 714.745n 1.1v 714.755n 1.1v 719.745n 1.1v 719.755n 1.1v 724.745n 1.1v 724.755n 0.0v 729.745n 0.0v 729.755n 1.1v 734.745n 1.1v 734.755n 1.1v 739.745n 1.1v 739.755n 1.1v 744.745n 1.1v 744.755n 1.1v 749.745n 1.1v 749.755n 0.0v 754.745n 0.0v 754.755n 1.1v 759.745n 1.1v 759.755n 0.0v 764.745n 0.0v 764.755n 1.1v 769.745n 1.1v 769.755n 1.1v 774.745n 1.1v 774.755n 1.1v 779.745n 1.1v 779.755n 1.1v 784.745n 1.1v 784.755n 0.0v 789.745n 0.0v 789.755n 0.0v 794.745n 0.0v 794.755n 0.0v 799.745n 0.0v 799.755n 0.0v 804.745n 0.0v 804.755n 0.0v 809.745n 0.0v 809.755n 0.0v 814.745n 0.0v 814.755n 1.1v 819.745n 1.1v 819.755n 1.1v 824.745n 1.1v 824.755n 1.1v 829.745n 1.1v 829.755n 0.0v 834.745n 0.0v 834.755n 1.1v 839.745n 1.1v 839.755n 0.0v 844.745n 0.0v 844.755n 0.0v 849.745n 0.0v 849.755n 0.0v 854.745n 0.0v 854.755n 1.1v 859.745n 1.1v 859.755n 0.0v 864.745n 0.0v 864.755n 1.1v 869.745n 1.1v 869.755n 0.0v 874.745n 0.0v 874.755n 0.0v 879.745n 0.0v 879.755n 1.1v 884.745n 1.1v 884.755n 1.1v 889.745n 1.1v 889.755n 1.1v 894.745n 1.1v 894.755n 1.1v 899.745n 1.1v 899.755n 1.1v 904.745n 1.1v 904.755n 1.1v 909.745n 1.1v 909.755n 0.0v 914.745n 0.0v 914.755n 0.0v 919.745n 0.0v 919.755n 0.0v 924.745n 0.0v 924.755n 1.1v 929.745n 1.1v 929.755n 0.0v 934.745n 0.0v 934.755n 0.0v 939.745n 0.0v 939.755n 0.0v 944.745n 0.0v 944.755n 0.0v 949.745n 0.0v 949.755n 0.0v 954.745n 0.0v 954.755n 0.0v 959.745n 0.0v 959.755n 0.0v 964.745n 0.0v 964.755n 0.0v 969.745n 0.0v 969.755n 1.1v 974.745n 1.1v 974.755n 1.1v 979.745n 1.1v 979.755n 0.0v 984.745n 0.0v 984.755n 1.1v 989.745n 1.1v 989.755n 1.1v 994.745n 1.1v 994.755n 0.0v 999.745n 0.0v 999.755n 0.0v 1004.745n 0.0v 1004.755n 1.1v 1009.745n 1.1v 1009.755n 1.1v 1014.745n 1.1v 1014.755n 1.1v 1019.745n 1.1v 1019.755n 0.0v 1024.745n 0.0v 1024.755n 0.0v )
* (time, data): [(0, 0), (5, 1), (10, 0), (15, 0), (20, 0), (25, 1), (30, 0), (35, 0), (40, 1), (45, 0), (50, 1), (55, 1), (60, 1), (65, 1), (70, 0), (75, 0), (80, 0), (85, 0), (90, 1), (95, 1), (100, 0), (105, 0), (110, 0), (115, 1), (120, 1), (125, 1), (130, 0), (135, 0), (140, 0), (145, 0), (150, 0), (155, 0), (160, 1), (165, 1), (170, 0), (175, 0), (180, 0), (185, 0), (190, 0), (195, 0), (200, 1), (205, 1), (210, 1), (215, 0), (220, 1), (225, 1), (230, 0), (235, 0), (240, 0), (245, 0), (250, 0), (255, 1), (260, 1), (265, 0), (270, 1), (275, 1), (280, 0), (285, 0), (290, 0), (295, 1), (300, 1), (305, 0), (310, 0), (315, 0), (320, 0), (325, 1), (330, 1), (335, 1), (340, 0), (345, 1), (350, 1), (355, 0), (360, 1), (365, 1), (370, 0), (375, 0), (380, 0), (385, 0), (390, 0), (395, 0), (400, 0), (405, 0), (410, 1), (415, 0), (420, 1), (425, 0), (430, 0), (435, 0), (440, 0), (445, 1), (450, 0), (455, 1), (460, 1), (465, 1), (470, 0), (475, 0), (480, 0), (485, 0), (490, 0), (495, 0), (500, 1), (505, 1), (510, 1), (515, 1), (520, 0), (525, 0), (530, 0), (535, 1), (540, 1), (545, 1), (550, 1), (555, 1), (560, 1), (565, 1), (570, 1), (575, 1), (580, 1), (585, 1), (590, 1), (595, 1), (600, 0), (605, 0), (610, 0), (615, 0), (620, 1), (625, 1), (630, 1), (635, 1), (640, 0), (645, 1), (650, 1), (655, 1), (660, 1), (665, 0), (670, 1), (675, 1), (680, 1), (685, 0), (690, 0), (695, 0), (700, 0), (705, 0), (710, 0), (715, 0), (720, 0), (725, 0), (730, 0), (735, 0), (740, 0), (745, 0), (750, 0), (755, 1), (760, 1), (765, 1), (770, 1), (775, 1), (780, 1), (785, 1), (790, 0), (795, 0), (800, 0), (805, 0), (810, 1), (815, 1), (820, 0), (825, 0), (830, 0), (835, 1), (840, 1), (845, 1), (850, 1), (855, 1), (860, 1), (865, 0), (870, 1), (875, 0), (880, 0), (885, 0), (890, 0), (895, 1), (900, 0), (905, 1), (910, 0), (915, 1), (920, 0), (925, 1), (930, 1), (935, 1), (940, 1), (945, 1), (950, 0), (955, 0), (960, 0), (965, 1), (970, 0), (975, 0), (980, 0), (985, 0), (990, 1), (995, 1), (1000, 1), (1005, 1), (1010, 1), (1015, 1), (1020, 1), (1025, 1)]
Va0_1  a0_1  0 PWL (0n 0.0v 4.745n 0.0v 4.755n 1.1v 9.745n 1.1v 9.755n 0.0v 14.745n 0.0v 14.755n 0.0v 19.745n 0.0v 19.755n 0.0v 24.745n 0.0v 24.755n 1.1v 29.745n 1.1v 29.755n 0.0v 34.745n 0.0v 34.755n 0.0v 39.745n 0.0v 39.755n 1.1v 44.745n 1.1v 44.755n 0.0v 49.745n 0.0v 49.755n 1.1v 54.745n 1.1v 54.755n 1.1v 59.745n 1.1v 59.755n 1.1v 64.745n 1.1v 64.755n 1.1v 69.745n 1.1v 69.755n 0.0v 74.745n 0.0v 74.755n 0.0v 79.745n 0.0v 79.755n 0.0v 84.745n 0.0v 84.755n 0.0v 89.745n 0.0v 89.755n 1.1v 94.745n 1.1v 94.755n 1.1v 99.745n 1.1v 99.755n 0.0v 104.745n 0.0v 104.755n 0.0v 109.745n 0.0v 109.755n 0.0v 114.745n 0.0v 114.755n 1.1v 119.745n 1.1v 119.755n 1.1v 124.745n 1.1v 124.755n 1.1v 129.745n 1.1v 129.755n 0.0v 134.745n 0.0v 134.755n 0.0v 139.745n 0.0v 139.755n 0.0v 144.745n 0.0v 144.755n 0.0v 149.745n 0.0v 149.755n 0.0v 154.745n 0.0v 154.755n 0.0v 159.745n 0.0v 159.755n 1.1v 164.745n 1.1v 164.755n 1.1v 169.745n 1.1v 169.755n 0.0v 174.745n 0.0v 174.755n 0.0v 179.745n 0.0v 179.755n 0.0v 184.745n 0.0v 184.755n 0.0v 189.745n 0.0v 189.755n 0.0v 194.745n 0.0v 194.755n 0.0v 199.745n 0.0v 199.755n 1.1v 204.745n 1.1v 204.755n 1.1v 209.745n 1.1v 209.755n 1.1v 214.745n 1.1v 214.755n 0.0v 219.745n 0.0v 219.755n 1.1v 224.745n 1.1v 224.755n 1.1v 229.745n 1.1v 229.755n 0.0v 234.745n 0.0v 234.755n 0.0v 239.745n 0.0v 239.755n 0.0v 244.745n 0.0v 244.755n 0.0v 249.745n 0.0v 249.755n 0.0v 254.745n 0.0v 254.755n 1.1v 259.745n 1.1v 259.755n 1.1v 264.745n 1.1v 264.755n 0.0v 269.745n 0.0v 269.755n 1.1v 274.745n 1.1v 274.755n 1.1v 279.745n 1.1v 279.755n 0.0v 284.745n 0.0v 284.755n 0.0v 289.745n 0.0v 289.755n 0.0v 294.745n 0.0v 294.755n 1.1v 299.745n 1.1v 299.755n 1.1v 304.745n 1.1v 304.755n 0.0v 309.745n 0.0v 309.755n 0.0v 314.745n 0.0v 314.755n 0.0v 319.745n 0.0v 319.755n 0.0v 324.745n 0.0v 324.755n 1.1v 329.745n 1.1v 329.755n 1.1v 334.745n 1.1v 334.755n 1.1v 339.745n 1.1v 339.755n 0.0v 344.745n 0.0v 344.755n 1.1v 349.745n 1.1v 349.755n 1.1v 354.745n 1.1v 354.755n 0.0v 359.745n 0.0v 359.755n 1.1v 364.745n 1.1v 364.755n 1.1v 369.745n 1.1v 369.755n 0.0v 374.745n 0.0v 374.755n 0.0v 379.745n 0.0v 379.755n 0.0v 384.745n 0.0v 384.755n 0.0v 389.745n 0.0v 389.755n 0.0v 394.745n 0.0v 394.755n 0.0v 399.745n 0.0v 399.755n 0.0v 404.745n 0.0v 404.755n 0.0v 409.745n 0.0v 409.755n 1.1v 414.745n 1.1v 414.755n 0.0v 419.745n 0.0v 419.755n 1.1v 424.745n 1.1v 424.755n 0.0v 429.745n 0.0v 429.755n 0.0v 434.745n 0.0v 434.755n 0.0v 439.745n 0.0v 439.755n 0.0v 444.745n 0.0v 444.755n 1.1v 449.745n 1.1v 449.755n 0.0v 454.745n 0.0v 454.755n 1.1v 459.745n 1.1v 459.755n 1.1v 464.745n 1.1v 464.755n 1.1v 469.745n 1.1v 469.755n 0.0v 474.745n 0.0v 474.755n 0.0v 479.745n 0.0v 479.755n 0.0v 484.745n 0.0v 484.755n 0.0v 489.745n 0.0v 489.755n 0.0v 494.745n 0.0v 494.755n 0.0v 499.745n 0.0v 499.755n 1.1v 504.745n 1.1v 504.755n 1.1v 509.745n 1.1v 509.755n 1.1v 514.745n 1.1v 514.755n 1.1v 519.745n 1.1v 519.755n 0.0v 524.745n 0.0v 524.755n 0.0v 529.745n 0.0v 529.755n 0.0v 534.745n 0.0v 534.755n 1.1v 539.745n 1.1v 539.755n 1.1v 544.745n 1.1v 544.755n 1.1v 549.745n 1.1v 549.755n 1.1v 554.745n 1.1v 554.755n 1.1v 559.745n 1.1v 559.755n 1.1v 564.745n 1.1v 564.755n 1.1v 569.745n 1.1v 569.755n 1.1v 574.745n 1.1v 574.755n 1.1v 579.745n 1.1v 579.755n 1.1v 584.745n 1.1v 584.755n 1.1v 589.745n 1.1v 589.755n 1.1v 594.745n 1.1v 594.755n 1.1v 599.745n 1.1v 599.755n 0.0v 604.745n 0.0v 604.755n 0.0v 609.745n 0.0v 609.755n 0.0v 614.745n 0.0v 614.755n 0.0v 619.745n 0.0v 619.755n 1.1v 624.745n 1.1v 624.755n 1.1v 629.745n 1.1v 629.755n 1.1v 634.745n 1.1v 634.755n 1.1v 639.745n 1.1v 639.755n 0.0v 644.745n 0.0v 644.755n 1.1v 649.745n 1.1v 649.755n 1.1v 654.745n 1.1v 654.755n 1.1v 659.745n 1.1v 659.755n 1.1v 664.745n 1.1v 664.755n 0.0v 669.745n 0.0v 669.755n 1.1v 674.745n 1.1v 674.755n 1.1v 679.745n 1.1v 679.755n 1.1v 684.745n 1.1v 684.755n 0.0v 689.745n 0.0v 689.755n 0.0v 694.745n 0.0v 694.755n 0.0v 699.745n 0.0v 699.755n 0.0v 704.745n 0.0v 704.755n 0.0v 709.745n 0.0v 709.755n 0.0v 714.745n 0.0v 714.755n 0.0v 719.745n 0.0v 719.755n 0.0v 724.745n 0.0v 724.755n 0.0v 729.745n 0.0v 729.755n 0.0v 734.745n 0.0v 734.755n 0.0v 739.745n 0.0v 739.755n 0.0v 744.745n 0.0v 744.755n 0.0v 749.745n 0.0v 749.755n 0.0v 754.745n 0.0v 754.755n 1.1v 759.745n 1.1v 759.755n 1.1v 764.745n 1.1v 764.755n 1.1v 769.745n 1.1v 769.755n 1.1v 774.745n 1.1v 774.755n 1.1v 779.745n 1.1v 779.755n 1.1v 784.745n 1.1v 784.755n 1.1v 789.745n 1.1v 789.755n 0.0v 794.745n 0.0v 794.755n 0.0v 799.745n 0.0v 799.755n 0.0v 804.745n 0.0v 804.755n 0.0v 809.745n 0.0v 809.755n 1.1v 814.745n 1.1v 814.755n 1.1v 819.745n 1.1v 819.755n 0.0v 824.745n 0.0v 824.755n 0.0v 829.745n 0.0v 829.755n 0.0v 834.745n 0.0v 834.755n 1.1v 839.745n 1.1v 839.755n 1.1v 844.745n 1.1v 844.755n 1.1v 849.745n 1.1v 849.755n 1.1v 854.745n 1.1v 854.755n 1.1v 859.745n 1.1v 859.755n 1.1v 864.745n 1.1v 864.755n 0.0v 869.745n 0.0v 869.755n 1.1v 874.745n 1.1v 874.755n 0.0v 879.745n 0.0v 879.755n 0.0v 884.745n 0.0v 884.755n 0.0v 889.745n 0.0v 889.755n 0.0v 894.745n 0.0v 894.755n 1.1v 899.745n 1.1v 899.755n 0.0v 904.745n 0.0v 904.755n 1.1v 909.745n 1.1v 909.755n 0.0v 914.745n 0.0v 914.755n 1.1v 919.745n 1.1v 919.755n 0.0v 924.745n 0.0v 924.755n 1.1v 929.745n 1.1v 929.755n 1.1v 934.745n 1.1v 934.755n 1.1v 939.745n 1.1v 939.755n 1.1v 944.745n 1.1v 944.755n 1.1v 949.745n 1.1v 949.755n 0.0v 954.745n 0.0v 954.755n 0.0v 959.745n 0.0v 959.755n 0.0v 964.745n 0.0v 964.755n 1.1v 969.745n 1.1v 969.755n 0.0v 974.745n 0.0v 974.755n 0.0v 979.745n 0.0v 979.755n 0.0v 984.745n 0.0v 984.755n 0.0v 989.745n 0.0v 989.755n 1.1v 994.745n 1.1v 994.755n 1.1v 999.745n 1.1v 999.755n 1.1v 1004.745n 1.1v 1004.755n 1.1v 1009.745n 1.1v 1009.755n 1.1v 1014.745n 1.1v 1014.755n 1.1v 1019.745n 1.1v 1019.755n 1.1v 1024.745n 1.1v 1024.755n 1.1v )
* (time, data): [(0, 0), (5, 0), (10, 0), (15, 0), (20, 0), (25, 0), (30, 0), (35, 0), (40, 0), (45, 0), (50, 0), (55, 0), (60, 1), (65, 0), (70, 1), (75, 1), (80, 1), (85, 0), (90, 0), (95, 0), (100, 0), (105, 0), (110, 1), (115, 0), (120, 0), (125, 0), (130, 0), (135, 1), (140, 0), (145, 0), (150, 0), (155, 0), (160, 0), (165, 0), (170, 0), (175, 0), (180, 0), (185, 0), (190, 0), (195, 1), (200, 0), (205, 0), (210, 0), (215, 1), (220, 0), (225, 0), (230, 1), (235, 1), (240, 1), (245, 0), (250, 0), (255, 0), (260, 0), (265, 1), (270, 0), (275, 0), (280, 1), (285, 0), (290, 0), (295, 1), (300, 1), (305, 0), (310, 0), (315, 1), (320, 1), (325, 1), (330, 1), (335, 1), (340, 1), (345, 0), (350, 0), (355, 1), (360, 0), (365, 0), (370, 0), (375, 0), (380, 0), (385, 1), (390, 1), (395, 1), (400, 1), (405, 0), (410, 0), (415, 0), (420, 1), (425, 0), (430, 0), (435, 0), (440, 0), (445, 0), (450, 0), (455, 1), (460, 0), (465, 0), (470, 0), (475, 1), (480, 0), (485, 1), (490, 1), (495, 0), (500, 0), (505, 0), (510, 0), (515, 0), (520, 1), (525, 1), (530, 1), (535, 1), (540, 1), (545, 1), (550, 1), (555, 0), (560, 0), (565, 0), (570, 0), (575, 0), (580, 0), (585, 0), (590, 0), (595, 0), (600, 1), (605, 0), (610, 0), (615, 0), (620, 0), (625, 0), (630, 0), (635, 0), (640, 0), (645, 0), (650, 0), (655, 0), (660, 0), (665, 1), (670, 1), (675, 1), (680, 1), (685, 0), (690, 0), (695, 0), (700, 0), (705, 0), (710, 0), (715, 0), (720, 0), (725, 1), (730, 0), (735, 0), (740, 0), (745, 0), (750, 0), (755, 0), (760, 0), (765, 0), (770, 0), (775, 0), (780, 0), (785, 0), (790, 0), (795, 0), (800, 0), (805, 0), (810, 0), (815, 0), (820, 0), (825, 0), (830, 1), (835, 0), (840, 1), (845, 1), (850, 1), (855, 0), (860, 0), (865, 0), (870, 1), (875, 1), (880, 0), (885, 0), (890, 0), (895, 0), (900, 0), (905, 0), (910, 0), (915, 1), (920, 0), (925, 0), (930, 1), (935, 1), (940, 0), (945, 0), (950, 0), (955, 0), (960, 0), (965, 1), (970, 1), (975, 1), (980, 1), (985, 0), (990, 0), (995, 1), (1000, 0), (1005, 0), (1010, 0), (1015, 0), (1020, 0), (1025, 0)]
Va0_2  a0_2  0 PWL (0n 0.0v 4.745n 0.0v 4.755n 0.0v 9.745n 0.0v 9.755n 0.0v 14.745n 0.0v 14.755n 0.0v 19.745n 0.0v 19.755n 0.0v 24.745n 0.0v 24.755n 0.0v 29.745n 0.0v 29.755n 0.0v 34.745n 0.0v 34.755n 0.0v 39.745n 0.0v 39.755n 0.0v 44.745n 0.0v 44.755n 0.0v 49.745n 0.0v 49.755n 0.0v 54.745n 0.0v 54.755n 0.0v 59.745n 0.0v 59.755n 1.1v 64.745n 1.1v 64.755n 0.0v 69.745n 0.0v 69.755n 1.1v 74.745n 1.1v 74.755n 1.1v 79.745n 1.1v 79.755n 1.1v 84.745n 1.1v 84.755n 0.0v 89.745n 0.0v 89.755n 0.0v 94.745n 0.0v 94.755n 0.0v 99.745n 0.0v 99.755n 0.0v 104.745n 0.0v 104.755n 0.0v 109.745n 0.0v 109.755n 1.1v 114.745n 1.1v 114.755n 0.0v 119.745n 0.0v 119.755n 0.0v 124.745n 0.0v 124.755n 0.0v 129.745n 0.0v 129.755n 0.0v 134.745n 0.0v 134.755n 1.1v 139.745n 1.1v 139.755n 0.0v 144.745n 0.0v 144.755n 0.0v 149.745n 0.0v 149.755n 0.0v 154.745n 0.0v 154.755n 0.0v 159.745n 0.0v 159.755n 0.0v 164.745n 0.0v 164.755n 0.0v 169.745n 0.0v 169.755n 0.0v 174.745n 0.0v 174.755n 0.0v 179.745n 0.0v 179.755n 0.0v 184.745n 0.0v 184.755n 0.0v 189.745n 0.0v 189.755n 0.0v 194.745n 0.0v 194.755n 1.1v 199.745n 1.1v 199.755n 0.0v 204.745n 0.0v 204.755n 0.0v 209.745n 0.0v 209.755n 0.0v 214.745n 0.0v 214.755n 1.1v 219.745n 1.1v 219.755n 0.0v 224.745n 0.0v 224.755n 0.0v 229.745n 0.0v 229.755n 1.1v 234.745n 1.1v 234.755n 1.1v 239.745n 1.1v 239.755n 1.1v 244.745n 1.1v 244.755n 0.0v 249.745n 0.0v 249.755n 0.0v 254.745n 0.0v 254.755n 0.0v 259.745n 0.0v 259.755n 0.0v 264.745n 0.0v 264.755n 1.1v 269.745n 1.1v 269.755n 0.0v 274.745n 0.0v 274.755n 0.0v 279.745n 0.0v 279.755n 1.1v 284.745n 1.1v 284.755n 0.0v 289.745n 0.0v 289.755n 0.0v 294.745n 0.0v 294.755n 1.1v 299.745n 1.1v 299.755n 1.1v 304.745n 1.1v 304.755n 0.0v 309.745n 0.0v 309.755n 0.0v 314.745n 0.0v 314.755n 1.1v 319.745n 1.1v 319.755n 1.1v 324.745n 1.1v 324.755n 1.1v 329.745n 1.1v 329.755n 1.1v 334.745n 1.1v 334.755n 1.1v 339.745n 1.1v 339.755n 1.1v 344.745n 1.1v 344.755n 0.0v 349.745n 0.0v 349.755n 0.0v 354.745n 0.0v 354.755n 1.1v 359.745n 1.1v 359.755n 0.0v 364.745n 0.0v 364.755n 0.0v 369.745n 0.0v 369.755n 0.0v 374.745n 0.0v 374.755n 0.0v 379.745n 0.0v 379.755n 0.0v 384.745n 0.0v 384.755n 1.1v 389.745n 1.1v 389.755n 1.1v 394.745n 1.1v 394.755n 1.1v 399.745n 1.1v 399.755n 1.1v 404.745n 1.1v 404.755n 0.0v 409.745n 0.0v 409.755n 0.0v 414.745n 0.0v 414.755n 0.0v 419.745n 0.0v 419.755n 1.1v 424.745n 1.1v 424.755n 0.0v 429.745n 0.0v 429.755n 0.0v 434.745n 0.0v 434.755n 0.0v 439.745n 0.0v 439.755n 0.0v 444.745n 0.0v 444.755n 0.0v 449.745n 0.0v 449.755n 0.0v 454.745n 0.0v 454.755n 1.1v 459.745n 1.1v 459.755n 0.0v 464.745n 0.0v 464.755n 0.0v 469.745n 0.0v 469.755n 0.0v 474.745n 0.0v 474.755n 1.1v 479.745n 1.1v 479.755n 0.0v 484.745n 0.0v 484.755n 1.1v 489.745n 1.1v 489.755n 1.1v 494.745n 1.1v 494.755n 0.0v 499.745n 0.0v 499.755n 0.0v 504.745n 0.0v 504.755n 0.0v 509.745n 0.0v 509.755n 0.0v 514.745n 0.0v 514.755n 0.0v 519.745n 0.0v 519.755n 1.1v 524.745n 1.1v 524.755n 1.1v 529.745n 1.1v 529.755n 1.1v 534.745n 1.1v 534.755n 1.1v 539.745n 1.1v 539.755n 1.1v 544.745n 1.1v 544.755n 1.1v 549.745n 1.1v 549.755n 1.1v 554.745n 1.1v 554.755n 0.0v 559.745n 0.0v 559.755n 0.0v 564.745n 0.0v 564.755n 0.0v 569.745n 0.0v 569.755n 0.0v 574.745n 0.0v 574.755n 0.0v 579.745n 0.0v 579.755n 0.0v 584.745n 0.0v 584.755n 0.0v 589.745n 0.0v 589.755n 0.0v 594.745n 0.0v 594.755n 0.0v 599.745n 0.0v 599.755n 1.1v 604.745n 1.1v 604.755n 0.0v 609.745n 0.0v 609.755n 0.0v 614.745n 0.0v 614.755n 0.0v 619.745n 0.0v 619.755n 0.0v 624.745n 0.0v 624.755n 0.0v 629.745n 0.0v 629.755n 0.0v 634.745n 0.0v 634.755n 0.0v 639.745n 0.0v 639.755n 0.0v 644.745n 0.0v 644.755n 0.0v 649.745n 0.0v 649.755n 0.0v 654.745n 0.0v 654.755n 0.0v 659.745n 0.0v 659.755n 0.0v 664.745n 0.0v 664.755n 1.1v 669.745n 1.1v 669.755n 1.1v 674.745n 1.1v 674.755n 1.1v 679.745n 1.1v 679.755n 1.1v 684.745n 1.1v 684.755n 0.0v 689.745n 0.0v 689.755n 0.0v 694.745n 0.0v 694.755n 0.0v 699.745n 0.0v 699.755n 0.0v 704.745n 0.0v 704.755n 0.0v 709.745n 0.0v 709.755n 0.0v 714.745n 0.0v 714.755n 0.0v 719.745n 0.0v 719.755n 0.0v 724.745n 0.0v 724.755n 1.1v 729.745n 1.1v 729.755n 0.0v 734.745n 0.0v 734.755n 0.0v 739.745n 0.0v 739.755n 0.0v 744.745n 0.0v 744.755n 0.0v 749.745n 0.0v 749.755n 0.0v 754.745n 0.0v 754.755n 0.0v 759.745n 0.0v 759.755n 0.0v 764.745n 0.0v 764.755n 0.0v 769.745n 0.0v 769.755n 0.0v 774.745n 0.0v 774.755n 0.0v 779.745n 0.0v 779.755n 0.0v 784.745n 0.0v 784.755n 0.0v 789.745n 0.0v 789.755n 0.0v 794.745n 0.0v 794.755n 0.0v 799.745n 0.0v 799.755n 0.0v 804.745n 0.0v 804.755n 0.0v 809.745n 0.0v 809.755n 0.0v 814.745n 0.0v 814.755n 0.0v 819.745n 0.0v 819.755n 0.0v 824.745n 0.0v 824.755n 0.0v 829.745n 0.0v 829.755n 1.1v 834.745n 1.1v 834.755n 0.0v 839.745n 0.0v 839.755n 1.1v 844.745n 1.1v 844.755n 1.1v 849.745n 1.1v 849.755n 1.1v 854.745n 1.1v 854.755n 0.0v 859.745n 0.0v 859.755n 0.0v 864.745n 0.0v 864.755n 0.0v 869.745n 0.0v 869.755n 1.1v 874.745n 1.1v 874.755n 1.1v 879.745n 1.1v 879.755n 0.0v 884.745n 0.0v 884.755n 0.0v 889.745n 0.0v 889.755n 0.0v 894.745n 0.0v 894.755n 0.0v 899.745n 0.0v 899.755n 0.0v 904.745n 0.0v 904.755n 0.0v 909.745n 0.0v 909.755n 0.0v 914.745n 0.0v 914.755n 1.1v 919.745n 1.1v 919.755n 0.0v 924.745n 0.0v 924.755n 0.0v 929.745n 0.0v 929.755n 1.1v 934.745n 1.1v 934.755n 1.1v 939.745n 1.1v 939.755n 0.0v 944.745n 0.0v 944.755n 0.0v 949.745n 0.0v 949.755n 0.0v 954.745n 0.0v 954.755n 0.0v 959.745n 0.0v 959.755n 0.0v 964.745n 0.0v 964.755n 1.1v 969.745n 1.1v 969.755n 1.1v 974.745n 1.1v 974.755n 1.1v 979.745n 1.1v 979.755n 1.1v 984.745n 1.1v 984.755n 0.0v 989.745n 0.0v 989.755n 0.0v 994.745n 0.0v 994.755n 1.1v 999.745n 1.1v 999.755n 0.0v 1004.745n 0.0v 1004.755n 0.0v 1009.745n 0.0v 1009.755n 0.0v 1014.745n 0.0v 1014.755n 0.0v 1019.745n 0.0v 1019.755n 0.0v 1024.745n 0.0v 1024.755n 0.0v )
* (time, data): [(0, 0), (5, 0), (10, 0), (15, 0), (20, 0), (25, 0), (30, 0), (35, 0), (40, 0), (45, 0), (50, 0), (55, 0), (60, 1), (65, 0), (70, 1), (75, 1), (80, 1), (85, 0), (90, 0), (95, 0), (100, 0), (105, 0), (110, 1), (115, 0), (120, 0), (125, 0), (130, 0), (135, 1), (140, 0), (145, 0), (150, 0), (155, 0), (160, 0), (165, 0), (170, 0), (175, 0), (180, 0), (185, 0), (190, 0), (195, 1), (200, 1), (205, 1), (210, 1), (215, 1), (220, 0), (225, 0), (230, 1), (235, 1), (240, 1), (245, 0), (250, 0), (255, 0), (260, 0), (265, 1), (270, 1), (275, 0), (280, 1), (285, 0), (290, 0), (295, 1), (300, 1), (305, 0), (310, 0), (315, 1), (320, 1), (325, 1), (330, 1), (335, 1), (340, 1), (345, 1), (350, 1), (355, 1), (360, 1), (365, 1), (370, 0), (375, 0), (380, 0), (385, 1), (390, 1), (395, 1), (400, 1), (405, 0), (410, 1), (415, 0), (420, 1), (425, 0), (430, 0), (435, 0), (440, 0), (445, 0), (450, 0), (455, 1), (460, 0), (465, 0), (470, 0), (475, 1), (480, 0), (485, 1), (490, 1), (495, 0), (500, 1), (505, 0), (510, 0), (515, 0), (520, 1), (525, 1), (530, 1), (535, 1), (540, 1), (545, 1), (550, 1), (555, 0), (560, 1), (565, 0), (570, 0), (575, 0), (580, 0), (585, 0), (590, 0), (595, 0), (600, 1), (605, 0), (610, 0), (615, 0), (620, 0), (625, 0), (630, 1), (635, 0), (640, 0), (645, 0), (650, 0), (655, 0), (660, 0), (665, 1), (670, 1), (675, 1), (680, 1), (685, 0), (690, 0), (695, 0), (700, 0), (705, 0), (710, 0), (715, 0), (720, 0), (725, 1), (730, 0), (735, 0), (740, 0), (745, 0), (750, 0), (755, 1), (760, 0), (765, 0), (770, 1), (775, 1), (780, 0), (785, 0), (790, 0), (795, 0), (800, 0), (805, 0), (810, 0), (815, 0), (820, 0), (825, 0), (830, 1), (835, 1), (840, 1), (845, 1), (850, 1), (855, 1), (860, 0), (865, 0), (870, 1), (875, 1), (880, 0), (885, 0), (890, 0), (895, 0), (900, 0), (905, 0), (910, 0), (915, 1), (920, 0), (925, 0), (930, 1), (935, 1), (940, 0), (945, 0), (950, 0), (955, 0), (960, 0), (965, 1), (970, 1), (975, 1), (980, 1), (985, 0), (990, 1), (995, 1), (1000, 0), (1005, 0), (1010, 1), (1015, 1), (1020, 0), (1025, 0)]
Va0_3  a0_3  0 PWL (0n 0.0v 4.745n 0.0v 4.755n 0.0v 9.745n 0.0v 9.755n 0.0v 14.745n 0.0v 14.755n 0.0v 19.745n 0.0v 19.755n 0.0v 24.745n 0.0v 24.755n 0.0v 29.745n 0.0v 29.755n 0.0v 34.745n 0.0v 34.755n 0.0v 39.745n 0.0v 39.755n 0.0v 44.745n 0.0v 44.755n 0.0v 49.745n 0.0v 49.755n 0.0v 54.745n 0.0v 54.755n 0.0v 59.745n 0.0v 59.755n 1.1v 64.745n 1.1v 64.755n 0.0v 69.745n 0.0v 69.755n 1.1v 74.745n 1.1v 74.755n 1.1v 79.745n 1.1v 79.755n 1.1v 84.745n 1.1v 84.755n 0.0v 89.745n 0.0v 89.755n 0.0v 94.745n 0.0v 94.755n 0.0v 99.745n 0.0v 99.755n 0.0v 104.745n 0.0v 104.755n 0.0v 109.745n 0.0v 109.755n 1.1v 114.745n 1.1v 114.755n 0.0v 119.745n 0.0v 119.755n 0.0v 124.745n 0.0v 124.755n 0.0v 129.745n 0.0v 129.755n 0.0v 134.745n 0.0v 134.755n 1.1v 139.745n 1.1v 139.755n 0.0v 144.745n 0.0v 144.755n 0.0v 149.745n 0.0v 149.755n 0.0v 154.745n 0.0v 154.755n 0.0v 159.745n 0.0v 159.755n 0.0v 164.745n 0.0v 164.755n 0.0v 169.745n 0.0v 169.755n 0.0v 174.745n 0.0v 174.755n 0.0v 179.745n 0.0v 179.755n 0.0v 184.745n 0.0v 184.755n 0.0v 189.745n 0.0v 189.755n 0.0v 194.745n 0.0v 194.755n 1.1v 199.745n 1.1v 199.755n 1.1v 204.745n 1.1v 204.755n 1.1v 209.745n 1.1v 209.755n 1.1v 214.745n 1.1v 214.755n 1.1v 219.745n 1.1v 219.755n 0.0v 224.745n 0.0v 224.755n 0.0v 229.745n 0.0v 229.755n 1.1v 234.745n 1.1v 234.755n 1.1v 239.745n 1.1v 239.755n 1.1v 244.745n 1.1v 244.755n 0.0v 249.745n 0.0v 249.755n 0.0v 254.745n 0.0v 254.755n 0.0v 259.745n 0.0v 259.755n 0.0v 264.745n 0.0v 264.755n 1.1v 269.745n 1.1v 269.755n 1.1v 274.745n 1.1v 274.755n 0.0v 279.745n 0.0v 279.755n 1.1v 284.745n 1.1v 284.755n 0.0v 289.745n 0.0v 289.755n 0.0v 294.745n 0.0v 294.755n 1.1v 299.745n 1.1v 299.755n 1.1v 304.745n 1.1v 304.755n 0.0v 309.745n 0.0v 309.755n 0.0v 314.745n 0.0v 314.755n 1.1v 319.745n 1.1v 319.755n 1.1v 324.745n 1.1v 324.755n 1.1v 329.745n 1.1v 329.755n 1.1v 334.745n 1.1v 334.755n 1.1v 339.745n 1.1v 339.755n 1.1v 344.745n 1.1v 344.755n 1.1v 349.745n 1.1v 349.755n 1.1v 354.745n 1.1v 354.755n 1.1v 359.745n 1.1v 359.755n 1.1v 364.745n 1.1v 364.755n 1.1v 369.745n 1.1v 369.755n 0.0v 374.745n 0.0v 374.755n 0.0v 379.745n 0.0v 379.755n 0.0v 384.745n 0.0v 384.755n 1.1v 389.745n 1.1v 389.755n 1.1v 394.745n 1.1v 394.755n 1.1v 399.745n 1.1v 399.755n 1.1v 404.745n 1.1v 404.755n 0.0v 409.745n 0.0v 409.755n 1.1v 414.745n 1.1v 414.755n 0.0v 419.745n 0.0v 419.755n 1.1v 424.745n 1.1v 424.755n 0.0v 429.745n 0.0v 429.755n 0.0v 434.745n 0.0v 434.755n 0.0v 439.745n 0.0v 439.755n 0.0v 444.745n 0.0v 444.755n 0.0v 449.745n 0.0v 449.755n 0.0v 454.745n 0.0v 454.755n 1.1v 459.745n 1.1v 459.755n 0.0v 464.745n 0.0v 464.755n 0.0v 469.745n 0.0v 469.755n 0.0v 474.745n 0.0v 474.755n 1.1v 479.745n 1.1v 479.755n 0.0v 484.745n 0.0v 484.755n 1.1v 489.745n 1.1v 489.755n 1.1v 494.745n 1.1v 494.755n 0.0v 499.745n 0.0v 499.755n 1.1v 504.745n 1.1v 504.755n 0.0v 509.745n 0.0v 509.755n 0.0v 514.745n 0.0v 514.755n 0.0v 519.745n 0.0v 519.755n 1.1v 524.745n 1.1v 524.755n 1.1v 529.745n 1.1v 529.755n 1.1v 534.745n 1.1v 534.755n 1.1v 539.745n 1.1v 539.755n 1.1v 544.745n 1.1v 544.755n 1.1v 549.745n 1.1v 549.755n 1.1v 554.745n 1.1v 554.755n 0.0v 559.745n 0.0v 559.755n 1.1v 564.745n 1.1v 564.755n 0.0v 569.745n 0.0v 569.755n 0.0v 574.745n 0.0v 574.755n 0.0v 579.745n 0.0v 579.755n 0.0v 584.745n 0.0v 584.755n 0.0v 589.745n 0.0v 589.755n 0.0v 594.745n 0.0v 594.755n 0.0v 599.745n 0.0v 599.755n 1.1v 604.745n 1.1v 604.755n 0.0v 609.745n 0.0v 609.755n 0.0v 614.745n 0.0v 614.755n 0.0v 619.745n 0.0v 619.755n 0.0v 624.745n 0.0v 624.755n 0.0v 629.745n 0.0v 629.755n 1.1v 634.745n 1.1v 634.755n 0.0v 639.745n 0.0v 639.755n 0.0v 644.745n 0.0v 644.755n 0.0v 649.745n 0.0v 649.755n 0.0v 654.745n 0.0v 654.755n 0.0v 659.745n 0.0v 659.755n 0.0v 664.745n 0.0v 664.755n 1.1v 669.745n 1.1v 669.755n 1.1v 674.745n 1.1v 674.755n 1.1v 679.745n 1.1v 679.755n 1.1v 684.745n 1.1v 684.755n 0.0v 689.745n 0.0v 689.755n 0.0v 694.745n 0.0v 694.755n 0.0v 699.745n 0.0v 699.755n 0.0v 704.745n 0.0v 704.755n 0.0v 709.745n 0.0v 709.755n 0.0v 714.745n 0.0v 714.755n 0.0v 719.745n 0.0v 719.755n 0.0v 724.745n 0.0v 724.755n 1.1v 729.745n 1.1v 729.755n 0.0v 734.745n 0.0v 734.755n 0.0v 739.745n 0.0v 739.755n 0.0v 744.745n 0.0v 744.755n 0.0v 749.745n 0.0v 749.755n 0.0v 754.745n 0.0v 754.755n 1.1v 759.745n 1.1v 759.755n 0.0v 764.745n 0.0v 764.755n 0.0v 769.745n 0.0v 769.755n 1.1v 774.745n 1.1v 774.755n 1.1v 779.745n 1.1v 779.755n 0.0v 784.745n 0.0v 784.755n 0.0v 789.745n 0.0v 789.755n 0.0v 794.745n 0.0v 794.755n 0.0v 799.745n 0.0v 799.755n 0.0v 804.745n 0.0v 804.755n 0.0v 809.745n 0.0v 809.755n 0.0v 814.745n 0.0v 814.755n 0.0v 819.745n 0.0v 819.755n 0.0v 824.745n 0.0v 824.755n 0.0v 829.745n 0.0v 829.755n 1.1v 834.745n 1.1v 834.755n 1.1v 839.745n 1.1v 839.755n 1.1v 844.745n 1.1v 844.755n 1.1v 849.745n 1.1v 849.755n 1.1v 854.745n 1.1v 854.755n 1.1v 859.745n 1.1v 859.755n 0.0v 864.745n 0.0v 864.755n 0.0v 869.745n 0.0v 869.755n 1.1v 874.745n 1.1v 874.755n 1.1v 879.745n 1.1v 879.755n 0.0v 884.745n 0.0v 884.755n 0.0v 889.745n 0.0v 889.755n 0.0v 894.745n 0.0v 894.755n 0.0v 899.745n 0.0v 899.755n 0.0v 904.745n 0.0v 904.755n 0.0v 909.745n 0.0v 909.755n 0.0v 914.745n 0.0v 914.755n 1.1v 919.745n 1.1v 919.755n 0.0v 924.745n 0.0v 924.755n 0.0v 929.745n 0.0v 929.755n 1.1v 934.745n 1.1v 934.755n 1.1v 939.745n 1.1v 939.755n 0.0v 944.745n 0.0v 944.755n 0.0v 949.745n 0.0v 949.755n 0.0v 954.745n 0.0v 954.755n 0.0v 959.745n 0.0v 959.755n 0.0v 964.745n 0.0v 964.755n 1.1v 969.745n 1.1v 969.755n 1.1v 974.745n 1.1v 974.755n 1.1v 979.745n 1.1v 979.755n 1.1v 984.745n 1.1v 984.755n 0.0v 989.745n 0.0v 989.755n 1.1v 994.745n 1.1v 994.755n 1.1v 999.745n 1.1v 999.755n 0.0v 1004.745n 0.0v 1004.755n 0.0v 1009.745n 0.0v 1009.755n 1.1v 1014.745n 1.1v 1014.755n 1.1v 1019.745n 1.1v 1019.755n 0.0v 1024.745n 0.0v 1024.755n 0.0v )
* (time, data): [(0, 0), (5, 0), (10, 0), (15, 0), (20, 0), (25, 0), (30, 0), (35, 0), (40, 0), (45, 0), (50, 0), (55, 0), (60, 1), (65, 0), (70, 1), (75, 1), (80, 1), (85, 0), (90, 0), (95, 0), (100, 0), (105, 0), (110, 1), (115, 0), (120, 0), (125, 0), (130, 0), (135, 1), (140, 0), (145, 0), (150, 0), (155, 0), (160, 0), (165, 0), (170, 0), (175, 0), (180, 0), (185, 0), (190, 0), (195, 1), (200, 1), (205, 1), (210, 1), (215, 1), (220, 0), (225, 0), (230, 1), (235, 1), (240, 1), (245, 0), (250, 0), (255, 0), (260, 0), (265, 1), (270, 1), (275, 0), (280, 1), (285, 0), (290, 0), (295, 1), (300, 1), (305, 0), (310, 0), (315, 1), (320, 1), (325, 1), (330, 1), (335, 1), (340, 1), (345, 1), (350, 1), (355, 1), (360, 1), (365, 1), (370, 0), (375, 0), (380, 0), (385, 1), (390, 1), (395, 1), (400, 1), (405, 0), (410, 1), (415, 0), (420, 1), (425, 0), (430, 0), (435, 0), (440, 0), (445, 0), (450, 0), (455, 1), (460, 0), (465, 0), (470, 0), (475, 1), (480, 0), (485, 1), (490, 1), (495, 0), (500, 1), (505, 0), (510, 0), (515, 0), (520, 1), (525, 1), (530, 1), (535, 1), (540, 1), (545, 1), (550, 1), (555, 0), (560, 1), (565, 0), (570, 0), (575, 0), (580, 0), (585, 0), (590, 0), (595, 0), (600, 1), (605, 0), (610, 0), (615, 0), (620, 0), (625, 0), (630, 1), (635, 0), (640, 0), (645, 0), (650, 0), (655, 0), (660, 0), (665, 1), (670, 1), (675, 1), (680, 1), (685, 0), (690, 0), (695, 0), (700, 0), (705, 0), (710, 0), (715, 0), (720, 0), (725, 1), (730, 0), (735, 0), (740, 0), (745, 0), (750, 0), (755, 1), (760, 0), (765, 0), (770, 1), (775, 1), (780, 0), (785, 0), (790, 0), (795, 0), (800, 0), (805, 0), (810, 0), (815, 0), (820, 0), (825, 0), (830, 1), (835, 1), (840, 1), (845, 1), (850, 1), (855, 1), (860, 0), (865, 0), (870, 1), (875, 1), (880, 0), (885, 0), (890, 0), (895, 0), (900, 0), (905, 0), (910, 0), (915, 1), (920, 0), (925, 0), (930, 1), (935, 1), (940, 0), (945, 0), (950, 0), (955, 0), (960, 0), (965, 1), (970, 1), (975, 1), (980, 1), (985, 0), (990, 1), (995, 1), (1000, 0), (1005, 0), (1010, 1), (1015, 1), (1020, 0), (1025, 0)]
Va0_4  a0_4  0 PWL (0n 0.0v 4.745n 0.0v 4.755n 0.0v 9.745n 0.0v 9.755n 0.0v 14.745n 0.0v 14.755n 0.0v 19.745n 0.0v 19.755n 0.0v 24.745n 0.0v 24.755n 0.0v 29.745n 0.0v 29.755n 0.0v 34.745n 0.0v 34.755n 0.0v 39.745n 0.0v 39.755n 0.0v 44.745n 0.0v 44.755n 0.0v 49.745n 0.0v 49.755n 0.0v 54.745n 0.0v 54.755n 0.0v 59.745n 0.0v 59.755n 1.1v 64.745n 1.1v 64.755n 0.0v 69.745n 0.0v 69.755n 1.1v 74.745n 1.1v 74.755n 1.1v 79.745n 1.1v 79.755n 1.1v 84.745n 1.1v 84.755n 0.0v 89.745n 0.0v 89.755n 0.0v 94.745n 0.0v 94.755n 0.0v 99.745n 0.0v 99.755n 0.0v 104.745n 0.0v 104.755n 0.0v 109.745n 0.0v 109.755n 1.1v 114.745n 1.1v 114.755n 0.0v 119.745n 0.0v 119.755n 0.0v 124.745n 0.0v 124.755n 0.0v 129.745n 0.0v 129.755n 0.0v 134.745n 0.0v 134.755n 1.1v 139.745n 1.1v 139.755n 0.0v 144.745n 0.0v 144.755n 0.0v 149.745n 0.0v 149.755n 0.0v 154.745n 0.0v 154.755n 0.0v 159.745n 0.0v 159.755n 0.0v 164.745n 0.0v 164.755n 0.0v 169.745n 0.0v 169.755n 0.0v 174.745n 0.0v 174.755n 0.0v 179.745n 0.0v 179.755n 0.0v 184.745n 0.0v 184.755n 0.0v 189.745n 0.0v 189.755n 0.0v 194.745n 0.0v 194.755n 1.1v 199.745n 1.1v 199.755n 1.1v 204.745n 1.1v 204.755n 1.1v 209.745n 1.1v 209.755n 1.1v 214.745n 1.1v 214.755n 1.1v 219.745n 1.1v 219.755n 0.0v 224.745n 0.0v 224.755n 0.0v 229.745n 0.0v 229.755n 1.1v 234.745n 1.1v 234.755n 1.1v 239.745n 1.1v 239.755n 1.1v 244.745n 1.1v 244.755n 0.0v 249.745n 0.0v 249.755n 0.0v 254.745n 0.0v 254.755n 0.0v 259.745n 0.0v 259.755n 0.0v 264.745n 0.0v 264.755n 1.1v 269.745n 1.1v 269.755n 1.1v 274.745n 1.1v 274.755n 0.0v 279.745n 0.0v 279.755n 1.1v 284.745n 1.1v 284.755n 0.0v 289.745n 0.0v 289.755n 0.0v 294.745n 0.0v 294.755n 1.1v 299.745n 1.1v 299.755n 1.1v 304.745n 1.1v 304.755n 0.0v 309.745n 0.0v 309.755n 0.0v 314.745n 0.0v 314.755n 1.1v 319.745n 1.1v 319.755n 1.1v 324.745n 1.1v 324.755n 1.1v 329.745n 1.1v 329.755n 1.1v 334.745n 1.1v 334.755n 1.1v 339.745n 1.1v 339.755n 1.1v 344.745n 1.1v 344.755n 1.1v 349.745n 1.1v 349.755n 1.1v 354.745n 1.1v 354.755n 1.1v 359.745n 1.1v 359.755n 1.1v 364.745n 1.1v 364.755n 1.1v 369.745n 1.1v 369.755n 0.0v 374.745n 0.0v 374.755n 0.0v 379.745n 0.0v 379.755n 0.0v 384.745n 0.0v 384.755n 1.1v 389.745n 1.1v 389.755n 1.1v 394.745n 1.1v 394.755n 1.1v 399.745n 1.1v 399.755n 1.1v 404.745n 1.1v 404.755n 0.0v 409.745n 0.0v 409.755n 1.1v 414.745n 1.1v 414.755n 0.0v 419.745n 0.0v 419.755n 1.1v 424.745n 1.1v 424.755n 0.0v 429.745n 0.0v 429.755n 0.0v 434.745n 0.0v 434.755n 0.0v 439.745n 0.0v 439.755n 0.0v 444.745n 0.0v 444.755n 0.0v 449.745n 0.0v 449.755n 0.0v 454.745n 0.0v 454.755n 1.1v 459.745n 1.1v 459.755n 0.0v 464.745n 0.0v 464.755n 0.0v 469.745n 0.0v 469.755n 0.0v 474.745n 0.0v 474.755n 1.1v 479.745n 1.1v 479.755n 0.0v 484.745n 0.0v 484.755n 1.1v 489.745n 1.1v 489.755n 1.1v 494.745n 1.1v 494.755n 0.0v 499.745n 0.0v 499.755n 1.1v 504.745n 1.1v 504.755n 0.0v 509.745n 0.0v 509.755n 0.0v 514.745n 0.0v 514.755n 0.0v 519.745n 0.0v 519.755n 1.1v 524.745n 1.1v 524.755n 1.1v 529.745n 1.1v 529.755n 1.1v 534.745n 1.1v 534.755n 1.1v 539.745n 1.1v 539.755n 1.1v 544.745n 1.1v 544.755n 1.1v 549.745n 1.1v 549.755n 1.1v 554.745n 1.1v 554.755n 0.0v 559.745n 0.0v 559.755n 1.1v 564.745n 1.1v 564.755n 0.0v 569.745n 0.0v 569.755n 0.0v 574.745n 0.0v 574.755n 0.0v 579.745n 0.0v 579.755n 0.0v 584.745n 0.0v 584.755n 0.0v 589.745n 0.0v 589.755n 0.0v 594.745n 0.0v 594.755n 0.0v 599.745n 0.0v 599.755n 1.1v 604.745n 1.1v 604.755n 0.0v 609.745n 0.0v 609.755n 0.0v 614.745n 0.0v 614.755n 0.0v 619.745n 0.0v 619.755n 0.0v 624.745n 0.0v 624.755n 0.0v 629.745n 0.0v 629.755n 1.1v 634.745n 1.1v 634.755n 0.0v 639.745n 0.0v 639.755n 0.0v 644.745n 0.0v 644.755n 0.0v 649.745n 0.0v 649.755n 0.0v 654.745n 0.0v 654.755n 0.0v 659.745n 0.0v 659.755n 0.0v 664.745n 0.0v 664.755n 1.1v 669.745n 1.1v 669.755n 1.1v 674.745n 1.1v 674.755n 1.1v 679.745n 1.1v 679.755n 1.1v 684.745n 1.1v 684.755n 0.0v 689.745n 0.0v 689.755n 0.0v 694.745n 0.0v 694.755n 0.0v 699.745n 0.0v 699.755n 0.0v 704.745n 0.0v 704.755n 0.0v 709.745n 0.0v 709.755n 0.0v 714.745n 0.0v 714.755n 0.0v 719.745n 0.0v 719.755n 0.0v 724.745n 0.0v 724.755n 1.1v 729.745n 1.1v 729.755n 0.0v 734.745n 0.0v 734.755n 0.0v 739.745n 0.0v 739.755n 0.0v 744.745n 0.0v 744.755n 0.0v 749.745n 0.0v 749.755n 0.0v 754.745n 0.0v 754.755n 1.1v 759.745n 1.1v 759.755n 0.0v 764.745n 0.0v 764.755n 0.0v 769.745n 0.0v 769.755n 1.1v 774.745n 1.1v 774.755n 1.1v 779.745n 1.1v 779.755n 0.0v 784.745n 0.0v 784.755n 0.0v 789.745n 0.0v 789.755n 0.0v 794.745n 0.0v 794.755n 0.0v 799.745n 0.0v 799.755n 0.0v 804.745n 0.0v 804.755n 0.0v 809.745n 0.0v 809.755n 0.0v 814.745n 0.0v 814.755n 0.0v 819.745n 0.0v 819.755n 0.0v 824.745n 0.0v 824.755n 0.0v 829.745n 0.0v 829.755n 1.1v 834.745n 1.1v 834.755n 1.1v 839.745n 1.1v 839.755n 1.1v 844.745n 1.1v 844.755n 1.1v 849.745n 1.1v 849.755n 1.1v 854.745n 1.1v 854.755n 1.1v 859.745n 1.1v 859.755n 0.0v 864.745n 0.0v 864.755n 0.0v 869.745n 0.0v 869.755n 1.1v 874.745n 1.1v 874.755n 1.1v 879.745n 1.1v 879.755n 0.0v 884.745n 0.0v 884.755n 0.0v 889.745n 0.0v 889.755n 0.0v 894.745n 0.0v 894.755n 0.0v 899.745n 0.0v 899.755n 0.0v 904.745n 0.0v 904.755n 0.0v 909.745n 0.0v 909.755n 0.0v 914.745n 0.0v 914.755n 1.1v 919.745n 1.1v 919.755n 0.0v 924.745n 0.0v 924.755n 0.0v 929.745n 0.0v 929.755n 1.1v 934.745n 1.1v 934.755n 1.1v 939.745n 1.1v 939.755n 0.0v 944.745n 0.0v 944.755n 0.0v 949.745n 0.0v 949.755n 0.0v 954.745n 0.0v 954.755n 0.0v 959.745n 0.0v 959.755n 0.0v 964.745n 0.0v 964.755n 1.1v 969.745n 1.1v 969.755n 1.1v 974.745n 1.1v 974.755n 1.1v 979.745n 1.1v 979.755n 1.1v 984.745n 1.1v 984.755n 0.0v 989.745n 0.0v 989.755n 1.1v 994.745n 1.1v 994.755n 1.1v 999.745n 1.1v 999.755n 0.0v 1004.745n 0.0v 1004.755n 0.0v 1009.745n 0.0v 1009.755n 1.1v 1014.745n 1.1v 1014.755n 1.1v 1019.745n 1.1v 1019.755n 0.0v 1024.745n 0.0v 1024.755n 0.0v )
* (time, data): [(0, 0), (5, 0), (10, 0), (15, 0), (20, 0), (25, 0), (30, 0), (35, 0), (40, 0), (45, 0), (50, 0), (55, 0), (60, 1), (65, 0), (70, 1), (75, 1), (80, 1), (85, 0), (90, 0), (95, 0), (100, 0), (105, 0), (110, 1), (115, 0), (120, 0), (125, 0), (130, 0), (135, 1), (140, 0), (145, 0), (150, 0), (155, 0), (160, 0), (165, 0), (170, 0), (175, 0), (180, 0), (185, 0), (190, 0), (195, 1), (200, 1), (205, 1), (210, 1), (215, 1), (220, 0), (225, 0), (230, 1), (235, 1), (240, 1), (245, 0), (250, 0), (255, 0), (260, 0), (265, 1), (270, 1), (275, 0), (280, 1), (285, 0), (290, 0), (295, 1), (300, 1), (305, 0), (310, 0), (315, 1), (320, 1), (325, 1), (330, 1), (335, 1), (340, 1), (345, 1), (350, 1), (355, 1), (360, 1), (365, 1), (370, 0), (375, 0), (380, 0), (385, 1), (390, 1), (395, 1), (400, 1), (405, 0), (410, 1), (415, 0), (420, 1), (425, 0), (430, 0), (435, 0), (440, 0), (445, 0), (450, 0), (455, 1), (460, 0), (465, 0), (470, 0), (475, 1), (480, 0), (485, 1), (490, 1), (495, 0), (500, 1), (505, 0), (510, 0), (515, 0), (520, 1), (525, 1), (530, 1), (535, 1), (540, 1), (545, 1), (550, 1), (555, 0), (560, 1), (565, 0), (570, 0), (575, 0), (580, 0), (585, 0), (590, 0), (595, 0), (600, 1), (605, 0), (610, 0), (615, 0), (620, 0), (625, 0), (630, 1), (635, 0), (640, 0), (645, 0), (650, 0), (655, 0), (660, 0), (665, 1), (670, 1), (675, 1), (680, 1), (685, 0), (690, 0), (695, 0), (700, 0), (705, 0), (710, 0), (715, 0), (720, 0), (725, 1), (730, 0), (735, 0), (740, 0), (745, 0), (750, 0), (755, 1), (760, 0), (765, 0), (770, 1), (775, 1), (780, 0), (785, 0), (790, 0), (795, 0), (800, 0), (805, 0), (810, 0), (815, 0), (820, 0), (825, 0), (830, 1), (835, 1), (840, 1), (845, 1), (850, 1), (855, 1), (860, 0), (865, 0), (870, 1), (875, 1), (880, 0), (885, 0), (890, 0), (895, 0), (900, 0), (905, 0), (910, 0), (915, 1), (920, 0), (925, 0), (930, 1), (935, 1), (940, 0), (945, 0), (950, 0), (955, 0), (960, 0), (965, 1), (970, 1), (975, 1), (980, 1), (985, 0), (990, 1), (995, 1), (1000, 0), (1005, 0), (1010, 1), (1015, 1), (1020, 0), (1025, 0)]
Va0_5  a0_5  0 PWL (0n 0.0v 4.745n 0.0v 4.755n 0.0v 9.745n 0.0v 9.755n 0.0v 14.745n 0.0v 14.755n 0.0v 19.745n 0.0v 19.755n 0.0v 24.745n 0.0v 24.755n 0.0v 29.745n 0.0v 29.755n 0.0v 34.745n 0.0v 34.755n 0.0v 39.745n 0.0v 39.755n 0.0v 44.745n 0.0v 44.755n 0.0v 49.745n 0.0v 49.755n 0.0v 54.745n 0.0v 54.755n 0.0v 59.745n 0.0v 59.755n 1.1v 64.745n 1.1v 64.755n 0.0v 69.745n 0.0v 69.755n 1.1v 74.745n 1.1v 74.755n 1.1v 79.745n 1.1v 79.755n 1.1v 84.745n 1.1v 84.755n 0.0v 89.745n 0.0v 89.755n 0.0v 94.745n 0.0v 94.755n 0.0v 99.745n 0.0v 99.755n 0.0v 104.745n 0.0v 104.755n 0.0v 109.745n 0.0v 109.755n 1.1v 114.745n 1.1v 114.755n 0.0v 119.745n 0.0v 119.755n 0.0v 124.745n 0.0v 124.755n 0.0v 129.745n 0.0v 129.755n 0.0v 134.745n 0.0v 134.755n 1.1v 139.745n 1.1v 139.755n 0.0v 144.745n 0.0v 144.755n 0.0v 149.745n 0.0v 149.755n 0.0v 154.745n 0.0v 154.755n 0.0v 159.745n 0.0v 159.755n 0.0v 164.745n 0.0v 164.755n 0.0v 169.745n 0.0v 169.755n 0.0v 174.745n 0.0v 174.755n 0.0v 179.745n 0.0v 179.755n 0.0v 184.745n 0.0v 184.755n 0.0v 189.745n 0.0v 189.755n 0.0v 194.745n 0.0v 194.755n 1.1v 199.745n 1.1v 199.755n 1.1v 204.745n 1.1v 204.755n 1.1v 209.745n 1.1v 209.755n 1.1v 214.745n 1.1v 214.755n 1.1v 219.745n 1.1v 219.755n 0.0v 224.745n 0.0v 224.755n 0.0v 229.745n 0.0v 229.755n 1.1v 234.745n 1.1v 234.755n 1.1v 239.745n 1.1v 239.755n 1.1v 244.745n 1.1v 244.755n 0.0v 249.745n 0.0v 249.755n 0.0v 254.745n 0.0v 254.755n 0.0v 259.745n 0.0v 259.755n 0.0v 264.745n 0.0v 264.755n 1.1v 269.745n 1.1v 269.755n 1.1v 274.745n 1.1v 274.755n 0.0v 279.745n 0.0v 279.755n 1.1v 284.745n 1.1v 284.755n 0.0v 289.745n 0.0v 289.755n 0.0v 294.745n 0.0v 294.755n 1.1v 299.745n 1.1v 299.755n 1.1v 304.745n 1.1v 304.755n 0.0v 309.745n 0.0v 309.755n 0.0v 314.745n 0.0v 314.755n 1.1v 319.745n 1.1v 319.755n 1.1v 324.745n 1.1v 324.755n 1.1v 329.745n 1.1v 329.755n 1.1v 334.745n 1.1v 334.755n 1.1v 339.745n 1.1v 339.755n 1.1v 344.745n 1.1v 344.755n 1.1v 349.745n 1.1v 349.755n 1.1v 354.745n 1.1v 354.755n 1.1v 359.745n 1.1v 359.755n 1.1v 364.745n 1.1v 364.755n 1.1v 369.745n 1.1v 369.755n 0.0v 374.745n 0.0v 374.755n 0.0v 379.745n 0.0v 379.755n 0.0v 384.745n 0.0v 384.755n 1.1v 389.745n 1.1v 389.755n 1.1v 394.745n 1.1v 394.755n 1.1v 399.745n 1.1v 399.755n 1.1v 404.745n 1.1v 404.755n 0.0v 409.745n 0.0v 409.755n 1.1v 414.745n 1.1v 414.755n 0.0v 419.745n 0.0v 419.755n 1.1v 424.745n 1.1v 424.755n 0.0v 429.745n 0.0v 429.755n 0.0v 434.745n 0.0v 434.755n 0.0v 439.745n 0.0v 439.755n 0.0v 444.745n 0.0v 444.755n 0.0v 449.745n 0.0v 449.755n 0.0v 454.745n 0.0v 454.755n 1.1v 459.745n 1.1v 459.755n 0.0v 464.745n 0.0v 464.755n 0.0v 469.745n 0.0v 469.755n 0.0v 474.745n 0.0v 474.755n 1.1v 479.745n 1.1v 479.755n 0.0v 484.745n 0.0v 484.755n 1.1v 489.745n 1.1v 489.755n 1.1v 494.745n 1.1v 494.755n 0.0v 499.745n 0.0v 499.755n 1.1v 504.745n 1.1v 504.755n 0.0v 509.745n 0.0v 509.755n 0.0v 514.745n 0.0v 514.755n 0.0v 519.745n 0.0v 519.755n 1.1v 524.745n 1.1v 524.755n 1.1v 529.745n 1.1v 529.755n 1.1v 534.745n 1.1v 534.755n 1.1v 539.745n 1.1v 539.755n 1.1v 544.745n 1.1v 544.755n 1.1v 549.745n 1.1v 549.755n 1.1v 554.745n 1.1v 554.755n 0.0v 559.745n 0.0v 559.755n 1.1v 564.745n 1.1v 564.755n 0.0v 569.745n 0.0v 569.755n 0.0v 574.745n 0.0v 574.755n 0.0v 579.745n 0.0v 579.755n 0.0v 584.745n 0.0v 584.755n 0.0v 589.745n 0.0v 589.755n 0.0v 594.745n 0.0v 594.755n 0.0v 599.745n 0.0v 599.755n 1.1v 604.745n 1.1v 604.755n 0.0v 609.745n 0.0v 609.755n 0.0v 614.745n 0.0v 614.755n 0.0v 619.745n 0.0v 619.755n 0.0v 624.745n 0.0v 624.755n 0.0v 629.745n 0.0v 629.755n 1.1v 634.745n 1.1v 634.755n 0.0v 639.745n 0.0v 639.755n 0.0v 644.745n 0.0v 644.755n 0.0v 649.745n 0.0v 649.755n 0.0v 654.745n 0.0v 654.755n 0.0v 659.745n 0.0v 659.755n 0.0v 664.745n 0.0v 664.755n 1.1v 669.745n 1.1v 669.755n 1.1v 674.745n 1.1v 674.755n 1.1v 679.745n 1.1v 679.755n 1.1v 684.745n 1.1v 684.755n 0.0v 689.745n 0.0v 689.755n 0.0v 694.745n 0.0v 694.755n 0.0v 699.745n 0.0v 699.755n 0.0v 704.745n 0.0v 704.755n 0.0v 709.745n 0.0v 709.755n 0.0v 714.745n 0.0v 714.755n 0.0v 719.745n 0.0v 719.755n 0.0v 724.745n 0.0v 724.755n 1.1v 729.745n 1.1v 729.755n 0.0v 734.745n 0.0v 734.755n 0.0v 739.745n 0.0v 739.755n 0.0v 744.745n 0.0v 744.755n 0.0v 749.745n 0.0v 749.755n 0.0v 754.745n 0.0v 754.755n 1.1v 759.745n 1.1v 759.755n 0.0v 764.745n 0.0v 764.755n 0.0v 769.745n 0.0v 769.755n 1.1v 774.745n 1.1v 774.755n 1.1v 779.745n 1.1v 779.755n 0.0v 784.745n 0.0v 784.755n 0.0v 789.745n 0.0v 789.755n 0.0v 794.745n 0.0v 794.755n 0.0v 799.745n 0.0v 799.755n 0.0v 804.745n 0.0v 804.755n 0.0v 809.745n 0.0v 809.755n 0.0v 814.745n 0.0v 814.755n 0.0v 819.745n 0.0v 819.755n 0.0v 824.745n 0.0v 824.755n 0.0v 829.745n 0.0v 829.755n 1.1v 834.745n 1.1v 834.755n 1.1v 839.745n 1.1v 839.755n 1.1v 844.745n 1.1v 844.755n 1.1v 849.745n 1.1v 849.755n 1.1v 854.745n 1.1v 854.755n 1.1v 859.745n 1.1v 859.755n 0.0v 864.745n 0.0v 864.755n 0.0v 869.745n 0.0v 869.755n 1.1v 874.745n 1.1v 874.755n 1.1v 879.745n 1.1v 879.755n 0.0v 884.745n 0.0v 884.755n 0.0v 889.745n 0.0v 889.755n 0.0v 894.745n 0.0v 894.755n 0.0v 899.745n 0.0v 899.755n 0.0v 904.745n 0.0v 904.755n 0.0v 909.745n 0.0v 909.755n 0.0v 914.745n 0.0v 914.755n 1.1v 919.745n 1.1v 919.755n 0.0v 924.745n 0.0v 924.755n 0.0v 929.745n 0.0v 929.755n 1.1v 934.745n 1.1v 934.755n 1.1v 939.745n 1.1v 939.755n 0.0v 944.745n 0.0v 944.755n 0.0v 949.745n 0.0v 949.755n 0.0v 954.745n 0.0v 954.755n 0.0v 959.745n 0.0v 959.755n 0.0v 964.745n 0.0v 964.755n 1.1v 969.745n 1.1v 969.755n 1.1v 974.745n 1.1v 974.755n 1.1v 979.745n 1.1v 979.755n 1.1v 984.745n 1.1v 984.755n 0.0v 989.745n 0.0v 989.755n 1.1v 994.745n 1.1v 994.755n 1.1v 999.745n 1.1v 999.755n 0.0v 1004.745n 0.0v 1004.755n 0.0v 1009.745n 0.0v 1009.755n 1.1v 1014.745n 1.1v 1014.755n 1.1v 1019.745n 1.1v 1019.755n 0.0v 1024.745n 0.0v 1024.755n 0.0v )
* (time, data): [(0, 0), (5, 0), (10, 0), (15, 0), (20, 0), (25, 0), (30, 0), (35, 0), (40, 0), (45, 0), (50, 0), (55, 0), (60, 1), (65, 0), (70, 1), (75, 1), (80, 1), (85, 0), (90, 0), (95, 0), (100, 0), (105, 0), (110, 1), (115, 0), (120, 0), (125, 0), (130, 0), (135, 1), (140, 0), (145, 0), (150, 0), (155, 0), (160, 0), (165, 0), (170, 0), (175, 0), (180, 0), (185, 0), (190, 0), (195, 1), (200, 1), (205, 1), (210, 1), (215, 1), (220, 0), (225, 0), (230, 1), (235, 1), (240, 1), (245, 0), (250, 0), (255, 0), (260, 0), (265, 1), (270, 1), (275, 0), (280, 1), (285, 0), (290, 0), (295, 1), (300, 1), (305, 0), (310, 0), (315, 1), (320, 1), (325, 1), (330, 1), (335, 1), (340, 1), (345, 1), (350, 1), (355, 1), (360, 1), (365, 1), (370, 0), (375, 0), (380, 0), (385, 1), (390, 1), (395, 1), (400, 1), (405, 0), (410, 1), (415, 0), (420, 1), (425, 0), (430, 0), (435, 0), (440, 0), (445, 0), (450, 0), (455, 1), (460, 0), (465, 0), (470, 0), (475, 1), (480, 0), (485, 1), (490, 1), (495, 0), (500, 1), (505, 0), (510, 0), (515, 0), (520, 1), (525, 1), (530, 1), (535, 1), (540, 1), (545, 1), (550, 1), (555, 0), (560, 1), (565, 0), (570, 0), (575, 0), (580, 0), (585, 0), (590, 0), (595, 0), (600, 1), (605, 0), (610, 0), (615, 0), (620, 0), (625, 0), (630, 1), (635, 0), (640, 0), (645, 0), (650, 0), (655, 0), (660, 0), (665, 1), (670, 1), (675, 1), (680, 1), (685, 0), (690, 0), (695, 0), (700, 0), (705, 0), (710, 0), (715, 0), (720, 0), (725, 1), (730, 0), (735, 0), (740, 0), (745, 0), (750, 0), (755, 1), (760, 0), (765, 0), (770, 1), (775, 1), (780, 0), (785, 0), (790, 0), (795, 0), (800, 0), (805, 0), (810, 0), (815, 0), (820, 0), (825, 0), (830, 1), (835, 1), (840, 1), (845, 1), (850, 1), (855, 1), (860, 0), (865, 0), (870, 1), (875, 1), (880, 0), (885, 0), (890, 0), (895, 0), (900, 0), (905, 0), (910, 0), (915, 1), (920, 0), (925, 0), (930, 1), (935, 1), (940, 0), (945, 0), (950, 0), (955, 0), (960, 0), (965, 1), (970, 1), (975, 1), (980, 1), (985, 0), (990, 1), (995, 1), (1000, 0), (1005, 0), (1010, 1), (1015, 1), (1020, 0), (1025, 0)]
Va0_6  a0_6  0 PWL (0n 0.0v 4.745n 0.0v 4.755n 0.0v 9.745n 0.0v 9.755n 0.0v 14.745n 0.0v 14.755n 0.0v 19.745n 0.0v 19.755n 0.0v 24.745n 0.0v 24.755n 0.0v 29.745n 0.0v 29.755n 0.0v 34.745n 0.0v 34.755n 0.0v 39.745n 0.0v 39.755n 0.0v 44.745n 0.0v 44.755n 0.0v 49.745n 0.0v 49.755n 0.0v 54.745n 0.0v 54.755n 0.0v 59.745n 0.0v 59.755n 1.1v 64.745n 1.1v 64.755n 0.0v 69.745n 0.0v 69.755n 1.1v 74.745n 1.1v 74.755n 1.1v 79.745n 1.1v 79.755n 1.1v 84.745n 1.1v 84.755n 0.0v 89.745n 0.0v 89.755n 0.0v 94.745n 0.0v 94.755n 0.0v 99.745n 0.0v 99.755n 0.0v 104.745n 0.0v 104.755n 0.0v 109.745n 0.0v 109.755n 1.1v 114.745n 1.1v 114.755n 0.0v 119.745n 0.0v 119.755n 0.0v 124.745n 0.0v 124.755n 0.0v 129.745n 0.0v 129.755n 0.0v 134.745n 0.0v 134.755n 1.1v 139.745n 1.1v 139.755n 0.0v 144.745n 0.0v 144.755n 0.0v 149.745n 0.0v 149.755n 0.0v 154.745n 0.0v 154.755n 0.0v 159.745n 0.0v 159.755n 0.0v 164.745n 0.0v 164.755n 0.0v 169.745n 0.0v 169.755n 0.0v 174.745n 0.0v 174.755n 0.0v 179.745n 0.0v 179.755n 0.0v 184.745n 0.0v 184.755n 0.0v 189.745n 0.0v 189.755n 0.0v 194.745n 0.0v 194.755n 1.1v 199.745n 1.1v 199.755n 1.1v 204.745n 1.1v 204.755n 1.1v 209.745n 1.1v 209.755n 1.1v 214.745n 1.1v 214.755n 1.1v 219.745n 1.1v 219.755n 0.0v 224.745n 0.0v 224.755n 0.0v 229.745n 0.0v 229.755n 1.1v 234.745n 1.1v 234.755n 1.1v 239.745n 1.1v 239.755n 1.1v 244.745n 1.1v 244.755n 0.0v 249.745n 0.0v 249.755n 0.0v 254.745n 0.0v 254.755n 0.0v 259.745n 0.0v 259.755n 0.0v 264.745n 0.0v 264.755n 1.1v 269.745n 1.1v 269.755n 1.1v 274.745n 1.1v 274.755n 0.0v 279.745n 0.0v 279.755n 1.1v 284.745n 1.1v 284.755n 0.0v 289.745n 0.0v 289.755n 0.0v 294.745n 0.0v 294.755n 1.1v 299.745n 1.1v 299.755n 1.1v 304.745n 1.1v 304.755n 0.0v 309.745n 0.0v 309.755n 0.0v 314.745n 0.0v 314.755n 1.1v 319.745n 1.1v 319.755n 1.1v 324.745n 1.1v 324.755n 1.1v 329.745n 1.1v 329.755n 1.1v 334.745n 1.1v 334.755n 1.1v 339.745n 1.1v 339.755n 1.1v 344.745n 1.1v 344.755n 1.1v 349.745n 1.1v 349.755n 1.1v 354.745n 1.1v 354.755n 1.1v 359.745n 1.1v 359.755n 1.1v 364.745n 1.1v 364.755n 1.1v 369.745n 1.1v 369.755n 0.0v 374.745n 0.0v 374.755n 0.0v 379.745n 0.0v 379.755n 0.0v 384.745n 0.0v 384.755n 1.1v 389.745n 1.1v 389.755n 1.1v 394.745n 1.1v 394.755n 1.1v 399.745n 1.1v 399.755n 1.1v 404.745n 1.1v 404.755n 0.0v 409.745n 0.0v 409.755n 1.1v 414.745n 1.1v 414.755n 0.0v 419.745n 0.0v 419.755n 1.1v 424.745n 1.1v 424.755n 0.0v 429.745n 0.0v 429.755n 0.0v 434.745n 0.0v 434.755n 0.0v 439.745n 0.0v 439.755n 0.0v 444.745n 0.0v 444.755n 0.0v 449.745n 0.0v 449.755n 0.0v 454.745n 0.0v 454.755n 1.1v 459.745n 1.1v 459.755n 0.0v 464.745n 0.0v 464.755n 0.0v 469.745n 0.0v 469.755n 0.0v 474.745n 0.0v 474.755n 1.1v 479.745n 1.1v 479.755n 0.0v 484.745n 0.0v 484.755n 1.1v 489.745n 1.1v 489.755n 1.1v 494.745n 1.1v 494.755n 0.0v 499.745n 0.0v 499.755n 1.1v 504.745n 1.1v 504.755n 0.0v 509.745n 0.0v 509.755n 0.0v 514.745n 0.0v 514.755n 0.0v 519.745n 0.0v 519.755n 1.1v 524.745n 1.1v 524.755n 1.1v 529.745n 1.1v 529.755n 1.1v 534.745n 1.1v 534.755n 1.1v 539.745n 1.1v 539.755n 1.1v 544.745n 1.1v 544.755n 1.1v 549.745n 1.1v 549.755n 1.1v 554.745n 1.1v 554.755n 0.0v 559.745n 0.0v 559.755n 1.1v 564.745n 1.1v 564.755n 0.0v 569.745n 0.0v 569.755n 0.0v 574.745n 0.0v 574.755n 0.0v 579.745n 0.0v 579.755n 0.0v 584.745n 0.0v 584.755n 0.0v 589.745n 0.0v 589.755n 0.0v 594.745n 0.0v 594.755n 0.0v 599.745n 0.0v 599.755n 1.1v 604.745n 1.1v 604.755n 0.0v 609.745n 0.0v 609.755n 0.0v 614.745n 0.0v 614.755n 0.0v 619.745n 0.0v 619.755n 0.0v 624.745n 0.0v 624.755n 0.0v 629.745n 0.0v 629.755n 1.1v 634.745n 1.1v 634.755n 0.0v 639.745n 0.0v 639.755n 0.0v 644.745n 0.0v 644.755n 0.0v 649.745n 0.0v 649.755n 0.0v 654.745n 0.0v 654.755n 0.0v 659.745n 0.0v 659.755n 0.0v 664.745n 0.0v 664.755n 1.1v 669.745n 1.1v 669.755n 1.1v 674.745n 1.1v 674.755n 1.1v 679.745n 1.1v 679.755n 1.1v 684.745n 1.1v 684.755n 0.0v 689.745n 0.0v 689.755n 0.0v 694.745n 0.0v 694.755n 0.0v 699.745n 0.0v 699.755n 0.0v 704.745n 0.0v 704.755n 0.0v 709.745n 0.0v 709.755n 0.0v 714.745n 0.0v 714.755n 0.0v 719.745n 0.0v 719.755n 0.0v 724.745n 0.0v 724.755n 1.1v 729.745n 1.1v 729.755n 0.0v 734.745n 0.0v 734.755n 0.0v 739.745n 0.0v 739.755n 0.0v 744.745n 0.0v 744.755n 0.0v 749.745n 0.0v 749.755n 0.0v 754.745n 0.0v 754.755n 1.1v 759.745n 1.1v 759.755n 0.0v 764.745n 0.0v 764.755n 0.0v 769.745n 0.0v 769.755n 1.1v 774.745n 1.1v 774.755n 1.1v 779.745n 1.1v 779.755n 0.0v 784.745n 0.0v 784.755n 0.0v 789.745n 0.0v 789.755n 0.0v 794.745n 0.0v 794.755n 0.0v 799.745n 0.0v 799.755n 0.0v 804.745n 0.0v 804.755n 0.0v 809.745n 0.0v 809.755n 0.0v 814.745n 0.0v 814.755n 0.0v 819.745n 0.0v 819.755n 0.0v 824.745n 0.0v 824.755n 0.0v 829.745n 0.0v 829.755n 1.1v 834.745n 1.1v 834.755n 1.1v 839.745n 1.1v 839.755n 1.1v 844.745n 1.1v 844.755n 1.1v 849.745n 1.1v 849.755n 1.1v 854.745n 1.1v 854.755n 1.1v 859.745n 1.1v 859.755n 0.0v 864.745n 0.0v 864.755n 0.0v 869.745n 0.0v 869.755n 1.1v 874.745n 1.1v 874.755n 1.1v 879.745n 1.1v 879.755n 0.0v 884.745n 0.0v 884.755n 0.0v 889.745n 0.0v 889.755n 0.0v 894.745n 0.0v 894.755n 0.0v 899.745n 0.0v 899.755n 0.0v 904.745n 0.0v 904.755n 0.0v 909.745n 0.0v 909.755n 0.0v 914.745n 0.0v 914.755n 1.1v 919.745n 1.1v 919.755n 0.0v 924.745n 0.0v 924.755n 0.0v 929.745n 0.0v 929.755n 1.1v 934.745n 1.1v 934.755n 1.1v 939.745n 1.1v 939.755n 0.0v 944.745n 0.0v 944.755n 0.0v 949.745n 0.0v 949.755n 0.0v 954.745n 0.0v 954.755n 0.0v 959.745n 0.0v 959.755n 0.0v 964.745n 0.0v 964.755n 1.1v 969.745n 1.1v 969.755n 1.1v 974.745n 1.1v 974.755n 1.1v 979.745n 1.1v 979.755n 1.1v 984.745n 1.1v 984.755n 0.0v 989.745n 0.0v 989.755n 1.1v 994.745n 1.1v 994.755n 1.1v 999.745n 1.1v 999.755n 0.0v 1004.745n 0.0v 1004.755n 0.0v 1009.745n 0.0v 1009.755n 1.1v 1014.745n 1.1v 1014.755n 1.1v 1019.745n 1.1v 1019.755n 0.0v 1024.745n 0.0v 1024.755n 0.0v )

 * Generation of control signals
* (time, data): [(0, 1), (5, 0), (10, 0), (15, 0), (20, 0), (25, 0), (30, 0), (35, 0), (40, 0), (45, 0), (50, 0), (55, 0), (60, 0), (65, 0), (70, 0), (75, 1), (80, 1), (85, 0), (90, 0), (95, 1), (100, 0), (105, 1), (110, 0), (115, 0), (120, 1), (125, 0), (130, 0), (135, 0), (140, 0), (145, 0), (150, 1), (155, 1), (160, 0), (165, 0), (170, 0), (175, 0), (180, 1), (185, 0), (190, 1), (195, 0), (200, 0), (205, 1), (210, 1), (215, 0), (220, 0), (225, 0), (230, 0), (235, 1), (240, 1), (245, 0), (250, 1), (255, 0), (260, 1), (265, 0), (270, 0), (275, 0), (280, 0), (285, 0), (290, 0), (295, 0), (300, 0), (305, 0), (310, 1), (315, 0), (320, 1), (325, 0), (330, 0), (335, 0), (340, 0), (345, 0), (350, 0), (355, 0), (360, 0), (365, 1), (370, 0), (375, 0), (380, 1), (385, 0), (390, 1), (395, 1), (400, 1), (405, 0), (410, 0), (415, 0), (420, 0), (425, 0), (430, 0), (435, 0), (440, 1), (445, 0), (450, 0), (455, 0), (460, 0), (465, 0), (470, 0), (475, 0), (480, 0), (485, 0), (490, 1), (495, 0), (500, 0), (505, 0), (510, 0), (515, 1), (520, 0), (525, 1), (530, 1), (535, 0), (540, 0), (545, 1), (550, 1), (555, 0), (560, 0), (565, 0), (570, 0), (575, 1), (580, 0), (585, 0), (590, 1), (595, 0), (600, 0), (605, 0), (610, 0), (615, 1), (620, 0), (625, 0), (630, 0), (635, 0), (640, 0), (645, 0), (650, 0), (655, 0), (660, 1), (665, 0), (670, 0), (675, 1), (680, 1), (685, 0), (690, 0), (695, 0), (700, 1), (705, 1), (710, 1), (715, 0), (720, 0), (725, 0), (730, 0), (735, 1), (740, 1), (745, 1), (750, 0), (755, 0), (760, 0), (765, 0), (770, 0), (775, 1), (780, 0), (785, 0), (790, 0), (795, 0), (800, 1), (805, 1), (810, 0), (815, 0), (820, 0), (825, 1), (830, 0), (835, 0), (840, 0), (845, 1), (850, 1), (855, 0), (860, 0), (865, 0), (870, 0), (875, 0), (880, 0), (885, 1), (890, 1), (895, 0), (900, 0), (905, 0), (910, 0), (915, 0), (920, 0), (925, 0), (930, 0), (935, 0), (940, 0), (945, 0), (950, 0), (955, 1), (960, 1), (965, 0), (970, 0), (975, 1), (980, 0), (985, 0), (990, 0), (995, 0), (1000, 0), (1005, 0), (1010, 0), (1015, 0), (1020, 0), (1025, 1)]
VCSB0 CSB0 0 PWL (0n 1.1v 4.745n 1.1v 4.755n 0.0v 9.745n 0.0v 9.755n 0.0v 14.745n 0.0v 14.755n 0.0v 19.745n 0.0v 19.755n 0.0v 24.745n 0.0v 24.755n 0.0v 29.745n 0.0v 29.755n 0.0v 34.745n 0.0v 34.755n 0.0v 39.745n 0.0v 39.755n 0.0v 44.745n 0.0v 44.755n 0.0v 49.745n 0.0v 49.755n 0.0v 54.745n 0.0v 54.755n 0.0v 59.745n 0.0v 59.755n 0.0v 64.745n 0.0v 64.755n 0.0v 69.745n 0.0v 69.755n 0.0v 74.745n 0.0v 74.755n 1.1v 79.745n 1.1v 79.755n 1.1v 84.745n 1.1v 84.755n 0.0v 89.745n 0.0v 89.755n 0.0v 94.745n 0.0v 94.755n 1.1v 99.745n 1.1v 99.755n 0.0v 104.745n 0.0v 104.755n 1.1v 109.745n 1.1v 109.755n 0.0v 114.745n 0.0v 114.755n 0.0v 119.745n 0.0v 119.755n 1.1v 124.745n 1.1v 124.755n 0.0v 129.745n 0.0v 129.755n 0.0v 134.745n 0.0v 134.755n 0.0v 139.745n 0.0v 139.755n 0.0v 144.745n 0.0v 144.755n 0.0v 149.745n 0.0v 149.755n 1.1v 154.745n 1.1v 154.755n 1.1v 159.745n 1.1v 159.755n 0.0v 164.745n 0.0v 164.755n 0.0v 169.745n 0.0v 169.755n 0.0v 174.745n 0.0v 174.755n 0.0v 179.745n 0.0v 179.755n 1.1v 184.745n 1.1v 184.755n 0.0v 189.745n 0.0v 189.755n 1.1v 194.745n 1.1v 194.755n 0.0v 199.745n 0.0v 199.755n 0.0v 204.745n 0.0v 204.755n 1.1v 209.745n 1.1v 209.755n 1.1v 214.745n 1.1v 214.755n 0.0v 219.745n 0.0v 219.755n 0.0v 224.745n 0.0v 224.755n 0.0v 229.745n 0.0v 229.755n 0.0v 234.745n 0.0v 234.755n 1.1v 239.745n 1.1v 239.755n 1.1v 244.745n 1.1v 244.755n 0.0v 249.745n 0.0v 249.755n 1.1v 254.745n 1.1v 254.755n 0.0v 259.745n 0.0v 259.755n 1.1v 264.745n 1.1v 264.755n 0.0v 269.745n 0.0v 269.755n 0.0v 274.745n 0.0v 274.755n 0.0v 279.745n 0.0v 279.755n 0.0v 284.745n 0.0v 284.755n 0.0v 289.745n 0.0v 289.755n 0.0v 294.745n 0.0v 294.755n 0.0v 299.745n 0.0v 299.755n 0.0v 304.745n 0.0v 304.755n 0.0v 309.745n 0.0v 309.755n 1.1v 314.745n 1.1v 314.755n 0.0v 319.745n 0.0v 319.755n 1.1v 324.745n 1.1v 324.755n 0.0v 329.745n 0.0v 329.755n 0.0v 334.745n 0.0v 334.755n 0.0v 339.745n 0.0v 339.755n 0.0v 344.745n 0.0v 344.755n 0.0v 349.745n 0.0v 349.755n 0.0v 354.745n 0.0v 354.755n 0.0v 359.745n 0.0v 359.755n 0.0v 364.745n 0.0v 364.755n 1.1v 369.745n 1.1v 369.755n 0.0v 374.745n 0.0v 374.755n 0.0v 379.745n 0.0v 379.755n 1.1v 384.745n 1.1v 384.755n 0.0v 389.745n 0.0v 389.755n 1.1v 394.745n 1.1v 394.755n 1.1v 399.745n 1.1v 399.755n 1.1v 404.745n 1.1v 404.755n 0.0v 409.745n 0.0v 409.755n 0.0v 414.745n 0.0v 414.755n 0.0v 419.745n 0.0v 419.755n 0.0v 424.745n 0.0v 424.755n 0.0v 429.745n 0.0v 429.755n 0.0v 434.745n 0.0v 434.755n 0.0v 439.745n 0.0v 439.755n 1.1v 444.745n 1.1v 444.755n 0.0v 449.745n 0.0v 449.755n 0.0v 454.745n 0.0v 454.755n 0.0v 459.745n 0.0v 459.755n 0.0v 464.745n 0.0v 464.755n 0.0v 469.745n 0.0v 469.755n 0.0v 474.745n 0.0v 474.755n 0.0v 479.745n 0.0v 479.755n 0.0v 484.745n 0.0v 484.755n 0.0v 489.745n 0.0v 489.755n 1.1v 494.745n 1.1v 494.755n 0.0v 499.745n 0.0v 499.755n 0.0v 504.745n 0.0v 504.755n 0.0v 509.745n 0.0v 509.755n 0.0v 514.745n 0.0v 514.755n 1.1v 519.745n 1.1v 519.755n 0.0v 524.745n 0.0v 524.755n 1.1v 529.745n 1.1v 529.755n 1.1v 534.745n 1.1v 534.755n 0.0v 539.745n 0.0v 539.755n 0.0v 544.745n 0.0v 544.755n 1.1v 549.745n 1.1v 549.755n 1.1v 554.745n 1.1v 554.755n 0.0v 559.745n 0.0v 559.755n 0.0v 564.745n 0.0v 564.755n 0.0v 569.745n 0.0v 569.755n 0.0v 574.745n 0.0v 574.755n 1.1v 579.745n 1.1v 579.755n 0.0v 584.745n 0.0v 584.755n 0.0v 589.745n 0.0v 589.755n 1.1v 594.745n 1.1v 594.755n 0.0v 599.745n 0.0v 599.755n 0.0v 604.745n 0.0v 604.755n 0.0v 609.745n 0.0v 609.755n 0.0v 614.745n 0.0v 614.755n 1.1v 619.745n 1.1v 619.755n 0.0v 624.745n 0.0v 624.755n 0.0v 629.745n 0.0v 629.755n 0.0v 634.745n 0.0v 634.755n 0.0v 639.745n 0.0v 639.755n 0.0v 644.745n 0.0v 644.755n 0.0v 649.745n 0.0v 649.755n 0.0v 654.745n 0.0v 654.755n 0.0v 659.745n 0.0v 659.755n 1.1v 664.745n 1.1v 664.755n 0.0v 669.745n 0.0v 669.755n 0.0v 674.745n 0.0v 674.755n 1.1v 679.745n 1.1v 679.755n 1.1v 684.745n 1.1v 684.755n 0.0v 689.745n 0.0v 689.755n 0.0v 694.745n 0.0v 694.755n 0.0v 699.745n 0.0v 699.755n 1.1v 704.745n 1.1v 704.755n 1.1v 709.745n 1.1v 709.755n 1.1v 714.745n 1.1v 714.755n 0.0v 719.745n 0.0v 719.755n 0.0v 724.745n 0.0v 724.755n 0.0v 729.745n 0.0v 729.755n 0.0v 734.745n 0.0v 734.755n 1.1v 739.745n 1.1v 739.755n 1.1v 744.745n 1.1v 744.755n 1.1v 749.745n 1.1v 749.755n 0.0v 754.745n 0.0v 754.755n 0.0v 759.745n 0.0v 759.755n 0.0v 764.745n 0.0v 764.755n 0.0v 769.745n 0.0v 769.755n 0.0v 774.745n 0.0v 774.755n 1.1v 779.745n 1.1v 779.755n 0.0v 784.745n 0.0v 784.755n 0.0v 789.745n 0.0v 789.755n 0.0v 794.745n 0.0v 794.755n 0.0v 799.745n 0.0v 799.755n 1.1v 804.745n 1.1v 804.755n 1.1v 809.745n 1.1v 809.755n 0.0v 814.745n 0.0v 814.755n 0.0v 819.745n 0.0v 819.755n 0.0v 824.745n 0.0v 824.755n 1.1v 829.745n 1.1v 829.755n 0.0v 834.745n 0.0v 834.755n 0.0v 839.745n 0.0v 839.755n 0.0v 844.745n 0.0v 844.755n 1.1v 849.745n 1.1v 849.755n 1.1v 854.745n 1.1v 854.755n 0.0v 859.745n 0.0v 859.755n 0.0v 864.745n 0.0v 864.755n 0.0v 869.745n 0.0v 869.755n 0.0v 874.745n 0.0v 874.755n 0.0v 879.745n 0.0v 879.755n 0.0v 884.745n 0.0v 884.755n 1.1v 889.745n 1.1v 889.755n 1.1v 894.745n 1.1v 894.755n 0.0v 899.745n 0.0v 899.755n 0.0v 904.745n 0.0v 904.755n 0.0v 909.745n 0.0v 909.755n 0.0v 914.745n 0.0v 914.755n 0.0v 919.745n 0.0v 919.755n 0.0v 924.745n 0.0v 924.755n 0.0v 929.745n 0.0v 929.755n 0.0v 934.745n 0.0v 934.755n 0.0v 939.745n 0.0v 939.755n 0.0v 944.745n 0.0v 944.755n 0.0v 949.745n 0.0v 949.755n 0.0v 954.745n 0.0v 954.755n 1.1v 959.745n 1.1v 959.755n 1.1v 964.745n 1.1v 964.755n 0.0v 969.745n 0.0v 969.755n 0.0v 974.745n 0.0v 974.755n 1.1v 979.745n 1.1v 979.755n 0.0v 984.745n 0.0v 984.755n 0.0v 989.745n 0.0v 989.755n 0.0v 994.745n 0.0v 994.755n 0.0v 999.745n 0.0v 999.755n 0.0v 1004.745n 0.0v 1004.755n 0.0v 1009.745n 0.0v 1009.755n 0.0v 1014.745n 0.0v 1014.755n 0.0v 1019.745n 0.0v 1019.755n 0.0v 1024.745n 0.0v 1024.755n 1.1v )
* (time, data): [(0, 1), (5, 0), (10, 0), (15, 0), (20, 1), (25, 1), (30, 0), (35, 0), (40, 0), (45, 1), (50, 1), (55, 1), (60, 0), (65, 1), (70, 0), (75, 1), (80, 1), (85, 1), (90, 1), (95, 1), (100, 0), (105, 1), (110, 1), (115, 0), (120, 1), (125, 0), (130, 1), (135, 0), (140, 0), (145, 0), (150, 1), (155, 1), (160, 1), (165, 0), (170, 1), (175, 1), (180, 1), (185, 1), (190, 1), (195, 1), (200, 0), (205, 1), (210, 1), (215, 1), (220, 0), (225, 1), (230, 0), (235, 1), (240, 1), (245, 0), (250, 1), (255, 0), (260, 1), (265, 1), (270, 0), (275, 1), (280, 1), (285, 0), (290, 1), (295, 1), (300, 1), (305, 0), (310, 1), (315, 1), (320, 1), (325, 0), (330, 0), (335, 1), (340, 1), (345, 0), (350, 1), (355, 1), (360, 1), (365, 1), (370, 0), (375, 0), (380, 1), (385, 0), (390, 1), (395, 1), (400, 1), (405, 1), (410, 1), (415, 0), (420, 0), (425, 1), (430, 0), (435, 1), (440, 1), (445, 1), (450, 1), (455, 1), (460, 1), (465, 1), (470, 1), (475, 1), (480, 0), (485, 0), (490, 1), (495, 0), (500, 1), (505, 1), (510, 1), (515, 1), (520, 0), (525, 1), (530, 1), (535, 0), (540, 0), (545, 1), (550, 1), (555, 0), (560, 1), (565, 1), (570, 0), (575, 1), (580, 1), (585, 0), (590, 1), (595, 1), (600, 0), (605, 1), (610, 1), (615, 1), (620, 0), (625, 1), (630, 1), (635, 1), (640, 1), (645, 1), (650, 0), (655, 0), (660, 1), (665, 1), (670, 1), (675, 1), (680, 1), (685, 1), (690, 0), (695, 1), (700, 1), (705, 1), (710, 1), (715, 0), (720, 1), (725, 0), (730, 1), (735, 1), (740, 1), (745, 1), (750, 1), (755, 1), (760, 1), (765, 1), (770, 1), (775, 1), (780, 1), (785, 1), (790, 1), (795, 0), (800, 1), (805, 1), (810, 1), (815, 1), (820, 1), (825, 1), (830, 1), (835, 1), (840, 0), (845, 1), (850, 1), (855, 1), (860, 1), (865, 1), (870, 0), (875, 1), (880, 1), (885, 1), (890, 1), (895, 0), (900, 1), (905, 1), (910, 1), (915, 1), (920, 0), (925, 1), (930, 1), (935, 1), (940, 0), (945, 1), (950, 1), (955, 1), (960, 1), (965, 1), (970, 1), (975, 1), (980, 1), (985, 0), (990, 0), (995, 1), (1000, 1), (1005, 1), (1010, 1), (1015, 0), (1020, 0), (1025, 1)]
VWEB0 WEB0 0 PWL (0n 1.1v 4.745n 1.1v 4.755n 0.0v 9.745n 0.0v 9.755n 0.0v 14.745n 0.0v 14.755n 0.0v 19.745n 0.0v 19.755n 1.1v 24.745n 1.1v 24.755n 1.1v 29.745n 1.1v 29.755n 0.0v 34.745n 0.0v 34.755n 0.0v 39.745n 0.0v 39.755n 0.0v 44.745n 0.0v 44.755n 1.1v 49.745n 1.1v 49.755n 1.1v 54.745n 1.1v 54.755n 1.1v 59.745n 1.1v 59.755n 0.0v 64.745n 0.0v 64.755n 1.1v 69.745n 1.1v 69.755n 0.0v 74.745n 0.0v 74.755n 1.1v 79.745n 1.1v 79.755n 1.1v 84.745n 1.1v 84.755n 1.1v 89.745n 1.1v 89.755n 1.1v 94.745n 1.1v 94.755n 1.1v 99.745n 1.1v 99.755n 0.0v 104.745n 0.0v 104.755n 1.1v 109.745n 1.1v 109.755n 1.1v 114.745n 1.1v 114.755n 0.0v 119.745n 0.0v 119.755n 1.1v 124.745n 1.1v 124.755n 0.0v 129.745n 0.0v 129.755n 1.1v 134.745n 1.1v 134.755n 0.0v 139.745n 0.0v 139.755n 0.0v 144.745n 0.0v 144.755n 0.0v 149.745n 0.0v 149.755n 1.1v 154.745n 1.1v 154.755n 1.1v 159.745n 1.1v 159.755n 1.1v 164.745n 1.1v 164.755n 0.0v 169.745n 0.0v 169.755n 1.1v 174.745n 1.1v 174.755n 1.1v 179.745n 1.1v 179.755n 1.1v 184.745n 1.1v 184.755n 1.1v 189.745n 1.1v 189.755n 1.1v 194.745n 1.1v 194.755n 1.1v 199.745n 1.1v 199.755n 0.0v 204.745n 0.0v 204.755n 1.1v 209.745n 1.1v 209.755n 1.1v 214.745n 1.1v 214.755n 1.1v 219.745n 1.1v 219.755n 0.0v 224.745n 0.0v 224.755n 1.1v 229.745n 1.1v 229.755n 0.0v 234.745n 0.0v 234.755n 1.1v 239.745n 1.1v 239.755n 1.1v 244.745n 1.1v 244.755n 0.0v 249.745n 0.0v 249.755n 1.1v 254.745n 1.1v 254.755n 0.0v 259.745n 0.0v 259.755n 1.1v 264.745n 1.1v 264.755n 1.1v 269.745n 1.1v 269.755n 0.0v 274.745n 0.0v 274.755n 1.1v 279.745n 1.1v 279.755n 1.1v 284.745n 1.1v 284.755n 0.0v 289.745n 0.0v 289.755n 1.1v 294.745n 1.1v 294.755n 1.1v 299.745n 1.1v 299.755n 1.1v 304.745n 1.1v 304.755n 0.0v 309.745n 0.0v 309.755n 1.1v 314.745n 1.1v 314.755n 1.1v 319.745n 1.1v 319.755n 1.1v 324.745n 1.1v 324.755n 0.0v 329.745n 0.0v 329.755n 0.0v 334.745n 0.0v 334.755n 1.1v 339.745n 1.1v 339.755n 1.1v 344.745n 1.1v 344.755n 0.0v 349.745n 0.0v 349.755n 1.1v 354.745n 1.1v 354.755n 1.1v 359.745n 1.1v 359.755n 1.1v 364.745n 1.1v 364.755n 1.1v 369.745n 1.1v 369.755n 0.0v 374.745n 0.0v 374.755n 0.0v 379.745n 0.0v 379.755n 1.1v 384.745n 1.1v 384.755n 0.0v 389.745n 0.0v 389.755n 1.1v 394.745n 1.1v 394.755n 1.1v 399.745n 1.1v 399.755n 1.1v 404.745n 1.1v 404.755n 1.1v 409.745n 1.1v 409.755n 1.1v 414.745n 1.1v 414.755n 0.0v 419.745n 0.0v 419.755n 0.0v 424.745n 0.0v 424.755n 1.1v 429.745n 1.1v 429.755n 0.0v 434.745n 0.0v 434.755n 1.1v 439.745n 1.1v 439.755n 1.1v 444.745n 1.1v 444.755n 1.1v 449.745n 1.1v 449.755n 1.1v 454.745n 1.1v 454.755n 1.1v 459.745n 1.1v 459.755n 1.1v 464.745n 1.1v 464.755n 1.1v 469.745n 1.1v 469.755n 1.1v 474.745n 1.1v 474.755n 1.1v 479.745n 1.1v 479.755n 0.0v 484.745n 0.0v 484.755n 0.0v 489.745n 0.0v 489.755n 1.1v 494.745n 1.1v 494.755n 0.0v 499.745n 0.0v 499.755n 1.1v 504.745n 1.1v 504.755n 1.1v 509.745n 1.1v 509.755n 1.1v 514.745n 1.1v 514.755n 1.1v 519.745n 1.1v 519.755n 0.0v 524.745n 0.0v 524.755n 1.1v 529.745n 1.1v 529.755n 1.1v 534.745n 1.1v 534.755n 0.0v 539.745n 0.0v 539.755n 0.0v 544.745n 0.0v 544.755n 1.1v 549.745n 1.1v 549.755n 1.1v 554.745n 1.1v 554.755n 0.0v 559.745n 0.0v 559.755n 1.1v 564.745n 1.1v 564.755n 1.1v 569.745n 1.1v 569.755n 0.0v 574.745n 0.0v 574.755n 1.1v 579.745n 1.1v 579.755n 1.1v 584.745n 1.1v 584.755n 0.0v 589.745n 0.0v 589.755n 1.1v 594.745n 1.1v 594.755n 1.1v 599.745n 1.1v 599.755n 0.0v 604.745n 0.0v 604.755n 1.1v 609.745n 1.1v 609.755n 1.1v 614.745n 1.1v 614.755n 1.1v 619.745n 1.1v 619.755n 0.0v 624.745n 0.0v 624.755n 1.1v 629.745n 1.1v 629.755n 1.1v 634.745n 1.1v 634.755n 1.1v 639.745n 1.1v 639.755n 1.1v 644.745n 1.1v 644.755n 1.1v 649.745n 1.1v 649.755n 0.0v 654.745n 0.0v 654.755n 0.0v 659.745n 0.0v 659.755n 1.1v 664.745n 1.1v 664.755n 1.1v 669.745n 1.1v 669.755n 1.1v 674.745n 1.1v 674.755n 1.1v 679.745n 1.1v 679.755n 1.1v 684.745n 1.1v 684.755n 1.1v 689.745n 1.1v 689.755n 0.0v 694.745n 0.0v 694.755n 1.1v 699.745n 1.1v 699.755n 1.1v 704.745n 1.1v 704.755n 1.1v 709.745n 1.1v 709.755n 1.1v 714.745n 1.1v 714.755n 0.0v 719.745n 0.0v 719.755n 1.1v 724.745n 1.1v 724.755n 0.0v 729.745n 0.0v 729.755n 1.1v 734.745n 1.1v 734.755n 1.1v 739.745n 1.1v 739.755n 1.1v 744.745n 1.1v 744.755n 1.1v 749.745n 1.1v 749.755n 1.1v 754.745n 1.1v 754.755n 1.1v 759.745n 1.1v 759.755n 1.1v 764.745n 1.1v 764.755n 1.1v 769.745n 1.1v 769.755n 1.1v 774.745n 1.1v 774.755n 1.1v 779.745n 1.1v 779.755n 1.1v 784.745n 1.1v 784.755n 1.1v 789.745n 1.1v 789.755n 1.1v 794.745n 1.1v 794.755n 0.0v 799.745n 0.0v 799.755n 1.1v 804.745n 1.1v 804.755n 1.1v 809.745n 1.1v 809.755n 1.1v 814.745n 1.1v 814.755n 1.1v 819.745n 1.1v 819.755n 1.1v 824.745n 1.1v 824.755n 1.1v 829.745n 1.1v 829.755n 1.1v 834.745n 1.1v 834.755n 1.1v 839.745n 1.1v 839.755n 0.0v 844.745n 0.0v 844.755n 1.1v 849.745n 1.1v 849.755n 1.1v 854.745n 1.1v 854.755n 1.1v 859.745n 1.1v 859.755n 1.1v 864.745n 1.1v 864.755n 1.1v 869.745n 1.1v 869.755n 0.0v 874.745n 0.0v 874.755n 1.1v 879.745n 1.1v 879.755n 1.1v 884.745n 1.1v 884.755n 1.1v 889.745n 1.1v 889.755n 1.1v 894.745n 1.1v 894.755n 0.0v 899.745n 0.0v 899.755n 1.1v 904.745n 1.1v 904.755n 1.1v 909.745n 1.1v 909.755n 1.1v 914.745n 1.1v 914.755n 1.1v 919.745n 1.1v 919.755n 0.0v 924.745n 0.0v 924.755n 1.1v 929.745n 1.1v 929.755n 1.1v 934.745n 1.1v 934.755n 1.1v 939.745n 1.1v 939.755n 0.0v 944.745n 0.0v 944.755n 1.1v 949.745n 1.1v 949.755n 1.1v 954.745n 1.1v 954.755n 1.1v 959.745n 1.1v 959.755n 1.1v 964.745n 1.1v 964.755n 1.1v 969.745n 1.1v 969.755n 1.1v 974.745n 1.1v 974.755n 1.1v 979.745n 1.1v 979.755n 1.1v 984.745n 1.1v 984.755n 0.0v 989.745n 0.0v 989.755n 0.0v 994.745n 0.0v 994.755n 1.1v 999.745n 1.1v 999.755n 1.1v 1004.745n 1.1v 1004.755n 1.1v 1009.745n 1.1v 1009.755n 1.1v 1014.745n 1.1v 1014.755n 0.0v 1019.745n 0.0v 1019.755n 0.0v 1024.745n 0.0v 1024.755n 1.1v )
* PULSE: period=5
Vclk0 clk0 0 PULSE (0 1.1 4.995n 0.01n 0.01n 2.49n 5n)

 * Generation of dout measurements
* CHECK dout0_0 vdout0_0ck4 = 1.1 time = 25
* CHECK dout0_1 vdout0_1ck4 = 1.1 time = 25
* CHECK dout0_2 vdout0_2ck4 = 0 time = 25
* CHECK dout0_3 vdout0_3ck4 = 1.1 time = 25
* CHECK dout0_4 vdout0_4ck4 = 1.1 time = 25
* CHECK dout0_5 vdout0_5ck4 = 1.1 time = 25
* CHECK dout0_6 vdout0_6ck4 = 1.1 time = 25
* CHECK dout0_7 vdout0_7ck4 = 0 time = 25
* CHECK dout0_8 vdout0_8ck4 = 1.1 time = 25
* CHECK dout0_9 vdout0_9ck4 = 0 time = 25
* CHECK dout0_10 vdout0_10ck4 = 1.1 time = 25
* CHECK dout0_11 vdout0_11ck4 = 1.1 time = 25
* CHECK dout0_12 vdout0_12ck4 = 1.1 time = 25
* CHECK dout0_13 vdout0_13ck4 = 0 time = 25
* CHECK dout0_14 vdout0_14ck4 = 0 time = 25
* CHECK dout0_15 vdout0_15ck4 = 1.1 time = 25
* CHECK dout0_16 vdout0_16ck4 = 1.1 time = 25
* CHECK dout0_17 vdout0_17ck4 = 1.1 time = 25
* CHECK dout0_18 vdout0_18ck4 = 1.1 time = 25
* CHECK dout0_19 vdout0_19ck4 = 0 time = 25
* CHECK dout0_20 vdout0_20ck4 = 0 time = 25
* CHECK dout0_21 vdout0_21ck4 = 0 time = 25
* CHECK dout0_22 vdout0_22ck4 = 0 time = 25
* CHECK dout0_23 vdout0_23ck4 = 0 time = 25
* CHECK dout0_24 vdout0_24ck4 = 1.1 time = 25
* CHECK dout0_25 vdout0_25ck4 = 1.1 time = 25
* CHECK dout0_26 vdout0_26ck4 = 1.1 time = 25
* CHECK dout0_27 vdout0_27ck4 = 0 time = 25
* CHECK dout0_28 vdout0_28ck4 = 0 time = 25
* CHECK dout0_29 vdout0_29ck4 = 1.1 time = 25
* CHECK dout0_30 vdout0_30ck4 = 0 time = 25
* CHECK dout0_31 vdout0_31ck4 = 0 time = 25
* CHECK dout0_0 vdout0_0ck5 = 0 time = 30
* CHECK dout0_1 vdout0_1ck5 = 1.1 time = 30
* CHECK dout0_2 vdout0_2ck5 = 1.1 time = 30
* CHECK dout0_3 vdout0_3ck5 = 1.1 time = 30
* CHECK dout0_4 vdout0_4ck5 = 1.1 time = 30
* CHECK dout0_5 vdout0_5ck5 = 1.1 time = 30
* CHECK dout0_6 vdout0_6ck5 = 1.1 time = 30
* CHECK dout0_7 vdout0_7ck5 = 0 time = 30
* CHECK dout0_8 vdout0_8ck5 = 0 time = 30
* CHECK dout0_9 vdout0_9ck5 = 0 time = 30
* CHECK dout0_10 vdout0_10ck5 = 1.1 time = 30
* CHECK dout0_11 vdout0_11ck5 = 0 time = 30
* CHECK dout0_12 vdout0_12ck5 = 1.1 time = 30
* CHECK dout0_13 vdout0_13ck5 = 1.1 time = 30
* CHECK dout0_14 vdout0_14ck5 = 1.1 time = 30
* CHECK dout0_15 vdout0_15ck5 = 0 time = 30
* CHECK dout0_16 vdout0_16ck5 = 1.1 time = 30
* CHECK dout0_17 vdout0_17ck5 = 1.1 time = 30
* CHECK dout0_18 vdout0_18ck5 = 1.1 time = 30
* CHECK dout0_19 vdout0_19ck5 = 1.1 time = 30
* CHECK dout0_20 vdout0_20ck5 = 1.1 time = 30
* CHECK dout0_21 vdout0_21ck5 = 1.1 time = 30
* CHECK dout0_22 vdout0_22ck5 = 1.1 time = 30
* CHECK dout0_23 vdout0_23ck5 = 0 time = 30
* CHECK dout0_24 vdout0_24ck5 = 0 time = 30
* CHECK dout0_25 vdout0_25ck5 = 1.1 time = 30
* CHECK dout0_26 vdout0_26ck5 = 0 time = 30
* CHECK dout0_27 vdout0_27ck5 = 1.1 time = 30
* CHECK dout0_28 vdout0_28ck5 = 1.1 time = 30
* CHECK dout0_29 vdout0_29ck5 = 1.1 time = 30
* CHECK dout0_30 vdout0_30ck5 = 0 time = 30
* CHECK dout0_31 vdout0_31ck5 = 0 time = 30
* CHECK dout0_0 vdout0_0ck9 = 1.1 time = 50
* CHECK dout0_1 vdout0_1ck9 = 0 time = 50
* CHECK dout0_2 vdout0_2ck9 = 1.1 time = 50
* CHECK dout0_3 vdout0_3ck9 = 1.1 time = 50
* CHECK dout0_4 vdout0_4ck9 = 1.1 time = 50
* CHECK dout0_5 vdout0_5ck9 = 1.1 time = 50
* CHECK dout0_6 vdout0_6ck9 = 0 time = 50
* CHECK dout0_7 vdout0_7ck9 = 0 time = 50
* CHECK dout0_8 vdout0_8ck9 = 1.1 time = 50
* CHECK dout0_9 vdout0_9ck9 = 1.1 time = 50
* CHECK dout0_10 vdout0_10ck9 = 1.1 time = 50
* CHECK dout0_11 vdout0_11ck9 = 0 time = 50
* CHECK dout0_12 vdout0_12ck9 = 0 time = 50
* CHECK dout0_13 vdout0_13ck9 = 0 time = 50
* CHECK dout0_14 vdout0_14ck9 = 1.1 time = 50
* CHECK dout0_15 vdout0_15ck9 = 1.1 time = 50
* CHECK dout0_16 vdout0_16ck9 = 0 time = 50
* CHECK dout0_17 vdout0_17ck9 = 0 time = 50
* CHECK dout0_18 vdout0_18ck9 = 1.1 time = 50
* CHECK dout0_19 vdout0_19ck9 = 0 time = 50
* CHECK dout0_20 vdout0_20ck9 = 1.1 time = 50
* CHECK dout0_21 vdout0_21ck9 = 0 time = 50
* CHECK dout0_22 vdout0_22ck9 = 1.1 time = 50
* CHECK dout0_23 vdout0_23ck9 = 1.1 time = 50
* CHECK dout0_24 vdout0_24ck9 = 1.1 time = 50
* CHECK dout0_25 vdout0_25ck9 = 0 time = 50
* CHECK dout0_26 vdout0_26ck9 = 0 time = 50
* CHECK dout0_27 vdout0_27ck9 = 1.1 time = 50
* CHECK dout0_28 vdout0_28ck9 = 0 time = 50
* CHECK dout0_29 vdout0_29ck9 = 1.1 time = 50
* CHECK dout0_30 vdout0_30ck9 = 1.1 time = 50
* CHECK dout0_31 vdout0_31ck9 = 1.1 time = 50
* CHECK dout0_0 vdout0_0ck10 = 0 time = 55
* CHECK dout0_1 vdout0_1ck10 = 1.1 time = 55
* CHECK dout0_2 vdout0_2ck10 = 1.1 time = 55
* CHECK dout0_3 vdout0_3ck10 = 1.1 time = 55
* CHECK dout0_4 vdout0_4ck10 = 1.1 time = 55
* CHECK dout0_5 vdout0_5ck10 = 1.1 time = 55
* CHECK dout0_6 vdout0_6ck10 = 1.1 time = 55
* CHECK dout0_7 vdout0_7ck10 = 0 time = 55
* CHECK dout0_8 vdout0_8ck10 = 0 time = 55
* CHECK dout0_9 vdout0_9ck10 = 0 time = 55
* CHECK dout0_10 vdout0_10ck10 = 1.1 time = 55
* CHECK dout0_11 vdout0_11ck10 = 0 time = 55
* CHECK dout0_12 vdout0_12ck10 = 1.1 time = 55
* CHECK dout0_13 vdout0_13ck10 = 1.1 time = 55
* CHECK dout0_14 vdout0_14ck10 = 1.1 time = 55
* CHECK dout0_15 vdout0_15ck10 = 0 time = 55
* CHECK dout0_16 vdout0_16ck10 = 1.1 time = 55
* CHECK dout0_17 vdout0_17ck10 = 1.1 time = 55
* CHECK dout0_18 vdout0_18ck10 = 1.1 time = 55
* CHECK dout0_19 vdout0_19ck10 = 1.1 time = 55
* CHECK dout0_20 vdout0_20ck10 = 1.1 time = 55
* CHECK dout0_21 vdout0_21ck10 = 1.1 time = 55
* CHECK dout0_22 vdout0_22ck10 = 1.1 time = 55
* CHECK dout0_23 vdout0_23ck10 = 0 time = 55
* CHECK dout0_24 vdout0_24ck10 = 0 time = 55
* CHECK dout0_25 vdout0_25ck10 = 1.1 time = 55
* CHECK dout0_26 vdout0_26ck10 = 0 time = 55
* CHECK dout0_27 vdout0_27ck10 = 1.1 time = 55
* CHECK dout0_28 vdout0_28ck10 = 1.1 time = 55
* CHECK dout0_29 vdout0_29ck10 = 1.1 time = 55
* CHECK dout0_30 vdout0_30ck10 = 0 time = 55
* CHECK dout0_31 vdout0_31ck10 = 0 time = 55
* CHECK dout0_0 vdout0_0ck11 = 0 time = 60
* CHECK dout0_1 vdout0_1ck11 = 1.1 time = 60
* CHECK dout0_2 vdout0_2ck11 = 1.1 time = 60
* CHECK dout0_3 vdout0_3ck11 = 1.1 time = 60
* CHECK dout0_4 vdout0_4ck11 = 1.1 time = 60
* CHECK dout0_5 vdout0_5ck11 = 1.1 time = 60
* CHECK dout0_6 vdout0_6ck11 = 1.1 time = 60
* CHECK dout0_7 vdout0_7ck11 = 0 time = 60
* CHECK dout0_8 vdout0_8ck11 = 0 time = 60
* CHECK dout0_9 vdout0_9ck11 = 0 time = 60
* CHECK dout0_10 vdout0_10ck11 = 1.1 time = 60
* CHECK dout0_11 vdout0_11ck11 = 0 time = 60
* CHECK dout0_12 vdout0_12ck11 = 1.1 time = 60
* CHECK dout0_13 vdout0_13ck11 = 1.1 time = 60
* CHECK dout0_14 vdout0_14ck11 = 1.1 time = 60
* CHECK dout0_15 vdout0_15ck11 = 0 time = 60
* CHECK dout0_16 vdout0_16ck11 = 1.1 time = 60
* CHECK dout0_17 vdout0_17ck11 = 1.1 time = 60
* CHECK dout0_18 vdout0_18ck11 = 1.1 time = 60
* CHECK dout0_19 vdout0_19ck11 = 1.1 time = 60
* CHECK dout0_20 vdout0_20ck11 = 1.1 time = 60
* CHECK dout0_21 vdout0_21ck11 = 1.1 time = 60
* CHECK dout0_22 vdout0_22ck11 = 1.1 time = 60
* CHECK dout0_23 vdout0_23ck11 = 0 time = 60
* CHECK dout0_24 vdout0_24ck11 = 0 time = 60
* CHECK dout0_25 vdout0_25ck11 = 1.1 time = 60
* CHECK dout0_26 vdout0_26ck11 = 0 time = 60
* CHECK dout0_27 vdout0_27ck11 = 1.1 time = 60
* CHECK dout0_28 vdout0_28ck11 = 1.1 time = 60
* CHECK dout0_29 vdout0_29ck11 = 1.1 time = 60
* CHECK dout0_30 vdout0_30ck11 = 0 time = 60
* CHECK dout0_31 vdout0_31ck11 = 0 time = 60
* CHECK dout0_0 vdout0_0ck13 = 1.1 time = 70
* CHECK dout0_1 vdout0_1ck13 = 0 time = 70
* CHECK dout0_2 vdout0_2ck13 = 0 time = 70
* CHECK dout0_3 vdout0_3ck13 = 0 time = 70
* CHECK dout0_4 vdout0_4ck13 = 1.1 time = 70
* CHECK dout0_5 vdout0_5ck13 = 0 time = 70
* CHECK dout0_6 vdout0_6ck13 = 1.1 time = 70
* CHECK dout0_7 vdout0_7ck13 = 1.1 time = 70
* CHECK dout0_8 vdout0_8ck13 = 0 time = 70
* CHECK dout0_9 vdout0_9ck13 = 1.1 time = 70
* CHECK dout0_10 vdout0_10ck13 = 1.1 time = 70
* CHECK dout0_11 vdout0_11ck13 = 0 time = 70
* CHECK dout0_12 vdout0_12ck13 = 0 time = 70
* CHECK dout0_13 vdout0_13ck13 = 0 time = 70
* CHECK dout0_14 vdout0_14ck13 = 0 time = 70
* CHECK dout0_15 vdout0_15ck13 = 1.1 time = 70
* CHECK dout0_16 vdout0_16ck13 = 1.1 time = 70
* CHECK dout0_17 vdout0_17ck13 = 0 time = 70
* CHECK dout0_18 vdout0_18ck13 = 1.1 time = 70
* CHECK dout0_19 vdout0_19ck13 = 1.1 time = 70
* CHECK dout0_20 vdout0_20ck13 = 0 time = 70
* CHECK dout0_21 vdout0_21ck13 = 1.1 time = 70
* CHECK dout0_22 vdout0_22ck13 = 0 time = 70
* CHECK dout0_23 vdout0_23ck13 = 1.1 time = 70
* CHECK dout0_24 vdout0_24ck13 = 0 time = 70
* CHECK dout0_25 vdout0_25ck13 = 1.1 time = 70
* CHECK dout0_26 vdout0_26ck13 = 0 time = 70
* CHECK dout0_27 vdout0_27ck13 = 0 time = 70
* CHECK dout0_28 vdout0_28ck13 = 0 time = 70
* CHECK dout0_29 vdout0_29ck13 = 1.1 time = 70
* CHECK dout0_30 vdout0_30ck13 = 1.1 time = 70
* CHECK dout0_31 vdout0_31ck13 = 1.1 time = 70
* CHECK dout0_0 vdout0_0ck17 = 1.1 time = 90
* CHECK dout0_1 vdout0_1ck17 = 0 time = 90
* CHECK dout0_2 vdout0_2ck17 = 1.1 time = 90
* CHECK dout0_3 vdout0_3ck17 = 1.1 time = 90
* CHECK dout0_4 vdout0_4ck17 = 1.1 time = 90
* CHECK dout0_5 vdout0_5ck17 = 1.1 time = 90
* CHECK dout0_6 vdout0_6ck17 = 0 time = 90
* CHECK dout0_7 vdout0_7ck17 = 0 time = 90
* CHECK dout0_8 vdout0_8ck17 = 1.1 time = 90
* CHECK dout0_9 vdout0_9ck17 = 1.1 time = 90
* CHECK dout0_10 vdout0_10ck17 = 1.1 time = 90
* CHECK dout0_11 vdout0_11ck17 = 0 time = 90
* CHECK dout0_12 vdout0_12ck17 = 0 time = 90
* CHECK dout0_13 vdout0_13ck17 = 0 time = 90
* CHECK dout0_14 vdout0_14ck17 = 1.1 time = 90
* CHECK dout0_15 vdout0_15ck17 = 1.1 time = 90
* CHECK dout0_16 vdout0_16ck17 = 0 time = 90
* CHECK dout0_17 vdout0_17ck17 = 0 time = 90
* CHECK dout0_18 vdout0_18ck17 = 1.1 time = 90
* CHECK dout0_19 vdout0_19ck17 = 0 time = 90
* CHECK dout0_20 vdout0_20ck17 = 1.1 time = 90
* CHECK dout0_21 vdout0_21ck17 = 0 time = 90
* CHECK dout0_22 vdout0_22ck17 = 1.1 time = 90
* CHECK dout0_23 vdout0_23ck17 = 1.1 time = 90
* CHECK dout0_24 vdout0_24ck17 = 1.1 time = 90
* CHECK dout0_25 vdout0_25ck17 = 0 time = 90
* CHECK dout0_26 vdout0_26ck17 = 0 time = 90
* CHECK dout0_27 vdout0_27ck17 = 1.1 time = 90
* CHECK dout0_28 vdout0_28ck17 = 0 time = 90
* CHECK dout0_29 vdout0_29ck17 = 1.1 time = 90
* CHECK dout0_30 vdout0_30ck17 = 1.1 time = 90
* CHECK dout0_31 vdout0_31ck17 = 1.1 time = 90
* CHECK dout0_0 vdout0_0ck18 = 0 time = 95
* CHECK dout0_1 vdout0_1ck18 = 1.1 time = 95
* CHECK dout0_2 vdout0_2ck18 = 1.1 time = 95
* CHECK dout0_3 vdout0_3ck18 = 1.1 time = 95
* CHECK dout0_4 vdout0_4ck18 = 1.1 time = 95
* CHECK dout0_5 vdout0_5ck18 = 1.1 time = 95
* CHECK dout0_6 vdout0_6ck18 = 1.1 time = 95
* CHECK dout0_7 vdout0_7ck18 = 0 time = 95
* CHECK dout0_8 vdout0_8ck18 = 0 time = 95
* CHECK dout0_9 vdout0_9ck18 = 0 time = 95
* CHECK dout0_10 vdout0_10ck18 = 1.1 time = 95
* CHECK dout0_11 vdout0_11ck18 = 0 time = 95
* CHECK dout0_12 vdout0_12ck18 = 1.1 time = 95
* CHECK dout0_13 vdout0_13ck18 = 1.1 time = 95
* CHECK dout0_14 vdout0_14ck18 = 1.1 time = 95
* CHECK dout0_15 vdout0_15ck18 = 0 time = 95
* CHECK dout0_16 vdout0_16ck18 = 1.1 time = 95
* CHECK dout0_17 vdout0_17ck18 = 1.1 time = 95
* CHECK dout0_18 vdout0_18ck18 = 1.1 time = 95
* CHECK dout0_19 vdout0_19ck18 = 1.1 time = 95
* CHECK dout0_20 vdout0_20ck18 = 1.1 time = 95
* CHECK dout0_21 vdout0_21ck18 = 1.1 time = 95
* CHECK dout0_22 vdout0_22ck18 = 1.1 time = 95
* CHECK dout0_23 vdout0_23ck18 = 0 time = 95
* CHECK dout0_24 vdout0_24ck18 = 0 time = 95
* CHECK dout0_25 vdout0_25ck18 = 1.1 time = 95
* CHECK dout0_26 vdout0_26ck18 = 0 time = 95
* CHECK dout0_27 vdout0_27ck18 = 1.1 time = 95
* CHECK dout0_28 vdout0_28ck18 = 1.1 time = 95
* CHECK dout0_29 vdout0_29ck18 = 1.1 time = 95
* CHECK dout0_30 vdout0_30ck18 = 0 time = 95
* CHECK dout0_31 vdout0_31ck18 = 0 time = 95
* CHECK dout0_0 vdout0_0ck22 = 0 time = 115
* CHECK dout0_1 vdout0_1ck22 = 0 time = 115
* CHECK dout0_2 vdout0_2ck22 = 0 time = 115
* CHECK dout0_3 vdout0_3ck22 = 0 time = 115
* CHECK dout0_4 vdout0_4ck22 = 1.1 time = 115
* CHECK dout0_5 vdout0_5ck22 = 0 time = 115
* CHECK dout0_6 vdout0_6ck22 = 1.1 time = 115
* CHECK dout0_7 vdout0_7ck22 = 1.1 time = 115
* CHECK dout0_8 vdout0_8ck22 = 0 time = 115
* CHECK dout0_9 vdout0_9ck22 = 1.1 time = 115
* CHECK dout0_10 vdout0_10ck22 = 1.1 time = 115
* CHECK dout0_11 vdout0_11ck22 = 1.1 time = 115
* CHECK dout0_12 vdout0_12ck22 = 1.1 time = 115
* CHECK dout0_13 vdout0_13ck22 = 1.1 time = 115
* CHECK dout0_14 vdout0_14ck22 = 1.1 time = 115
* CHECK dout0_15 vdout0_15ck22 = 1.1 time = 115
* CHECK dout0_16 vdout0_16ck22 = 0 time = 115
* CHECK dout0_17 vdout0_17ck22 = 0 time = 115
* CHECK dout0_18 vdout0_18ck22 = 1.1 time = 115
* CHECK dout0_19 vdout0_19ck22 = 0 time = 115
* CHECK dout0_20 vdout0_20ck22 = 1.1 time = 115
* CHECK dout0_21 vdout0_21ck22 = 0 time = 115
* CHECK dout0_22 vdout0_22ck22 = 1.1 time = 115
* CHECK dout0_23 vdout0_23ck22 = 1.1 time = 115
* CHECK dout0_24 vdout0_24ck22 = 0 time = 115
* CHECK dout0_25 vdout0_25ck22 = 0 time = 115
* CHECK dout0_26 vdout0_26ck22 = 1.1 time = 115
* CHECK dout0_27 vdout0_27ck22 = 1.1 time = 115
* CHECK dout0_28 vdout0_28ck22 = 1.1 time = 115
* CHECK dout0_29 vdout0_29ck22 = 1.1 time = 115
* CHECK dout0_30 vdout0_30ck22 = 0 time = 115
* CHECK dout0_31 vdout0_31ck22 = 1.1 time = 115
* CHECK dout0_0 vdout0_0ck26 = 1.1 time = 135
* CHECK dout0_1 vdout0_1ck26 = 1.1 time = 135
* CHECK dout0_2 vdout0_2ck26 = 1.1 time = 135
* CHECK dout0_3 vdout0_3ck26 = 0 time = 135
* CHECK dout0_4 vdout0_4ck26 = 0 time = 135
* CHECK dout0_5 vdout0_5ck26 = 1.1 time = 135
* CHECK dout0_6 vdout0_6ck26 = 1.1 time = 135
* CHECK dout0_7 vdout0_7ck26 = 0 time = 135
* CHECK dout0_8 vdout0_8ck26 = 0 time = 135
* CHECK dout0_9 vdout0_9ck26 = 0 time = 135
* CHECK dout0_10 vdout0_10ck26 = 0 time = 135
* CHECK dout0_11 vdout0_11ck26 = 1.1 time = 135
* CHECK dout0_12 vdout0_12ck26 = 1.1 time = 135
* CHECK dout0_13 vdout0_13ck26 = 1.1 time = 135
* CHECK dout0_14 vdout0_14ck26 = 0 time = 135
* CHECK dout0_15 vdout0_15ck26 = 0 time = 135
* CHECK dout0_16 vdout0_16ck26 = 0 time = 135
* CHECK dout0_17 vdout0_17ck26 = 1.1 time = 135
* CHECK dout0_18 vdout0_18ck26 = 1.1 time = 135
* CHECK dout0_19 vdout0_19ck26 = 0 time = 135
* CHECK dout0_20 vdout0_20ck26 = 1.1 time = 135
* CHECK dout0_21 vdout0_21ck26 = 0 time = 135
* CHECK dout0_22 vdout0_22ck26 = 0 time = 135
* CHECK dout0_23 vdout0_23ck26 = 0 time = 135
* CHECK dout0_24 vdout0_24ck26 = 0 time = 135
* CHECK dout0_25 vdout0_25ck26 = 0 time = 135
* CHECK dout0_26 vdout0_26ck26 = 0 time = 135
* CHECK dout0_27 vdout0_27ck26 = 0 time = 135
* CHECK dout0_28 vdout0_28ck26 = 0 time = 135
* CHECK dout0_29 vdout0_29ck26 = 0 time = 135
* CHECK dout0_30 vdout0_30ck26 = 1.1 time = 135
* CHECK dout0_31 vdout0_31ck26 = 1.1 time = 135
* CHECK dout0_0 vdout0_0ck32 = 0 time = 165
* CHECK dout0_1 vdout0_1ck32 = 1.1 time = 165
* CHECK dout0_2 vdout0_2ck32 = 0 time = 165
* CHECK dout0_3 vdout0_3ck32 = 1.1 time = 165
* CHECK dout0_4 vdout0_4ck32 = 1.1 time = 165
* CHECK dout0_5 vdout0_5ck32 = 1.1 time = 165
* CHECK dout0_6 vdout0_6ck32 = 1.1 time = 165
* CHECK dout0_7 vdout0_7ck32 = 0 time = 165
* CHECK dout0_8 vdout0_8ck32 = 1.1 time = 165
* CHECK dout0_9 vdout0_9ck32 = 0 time = 165
* CHECK dout0_10 vdout0_10ck32 = 1.1 time = 165
* CHECK dout0_11 vdout0_11ck32 = 0 time = 165
* CHECK dout0_12 vdout0_12ck32 = 0 time = 165
* CHECK dout0_13 vdout0_13ck32 = 0 time = 165
* CHECK dout0_14 vdout0_14ck32 = 1.1 time = 165
* CHECK dout0_15 vdout0_15ck32 = 1.1 time = 165
* CHECK dout0_16 vdout0_16ck32 = 0 time = 165
* CHECK dout0_17 vdout0_17ck32 = 0 time = 165
* CHECK dout0_18 vdout0_18ck32 = 1.1 time = 165
* CHECK dout0_19 vdout0_19ck32 = 0 time = 165
* CHECK dout0_20 vdout0_20ck32 = 0 time = 165
* CHECK dout0_21 vdout0_21ck32 = 0 time = 165
* CHECK dout0_22 vdout0_22ck32 = 0 time = 165
* CHECK dout0_23 vdout0_23ck32 = 1.1 time = 165
* CHECK dout0_24 vdout0_24ck32 = 1.1 time = 165
* CHECK dout0_25 vdout0_25ck32 = 1.1 time = 165
* CHECK dout0_26 vdout0_26ck32 = 1.1 time = 165
* CHECK dout0_27 vdout0_27ck32 = 1.1 time = 165
* CHECK dout0_28 vdout0_28ck32 = 1.1 time = 165
* CHECK dout0_29 vdout0_29ck32 = 0 time = 165
* CHECK dout0_30 vdout0_30ck32 = 1.1 time = 165
* CHECK dout0_31 vdout0_31ck32 = 0 time = 165
* CHECK dout0_0 vdout0_0ck34 = 0 time = 175
* CHECK dout0_1 vdout0_1ck34 = 1.1 time = 175
* CHECK dout0_2 vdout0_2ck34 = 1.1 time = 175
* CHECK dout0_3 vdout0_3ck34 = 1.1 time = 175
* CHECK dout0_4 vdout0_4ck34 = 1.1 time = 175
* CHECK dout0_5 vdout0_5ck34 = 1.1 time = 175
* CHECK dout0_6 vdout0_6ck34 = 0 time = 175
* CHECK dout0_7 vdout0_7ck34 = 0 time = 175
* CHECK dout0_8 vdout0_8ck34 = 1.1 time = 175
* CHECK dout0_9 vdout0_9ck34 = 0 time = 175
* CHECK dout0_10 vdout0_10ck34 = 1.1 time = 175
* CHECK dout0_11 vdout0_11ck34 = 0 time = 175
* CHECK dout0_12 vdout0_12ck34 = 1.1 time = 175
* CHECK dout0_13 vdout0_13ck34 = 0 time = 175
* CHECK dout0_14 vdout0_14ck34 = 0 time = 175
* CHECK dout0_15 vdout0_15ck34 = 1.1 time = 175
* CHECK dout0_16 vdout0_16ck34 = 1.1 time = 175
* CHECK dout0_17 vdout0_17ck34 = 0 time = 175
* CHECK dout0_18 vdout0_18ck34 = 1.1 time = 175
* CHECK dout0_19 vdout0_19ck34 = 1.1 time = 175
* CHECK dout0_20 vdout0_20ck34 = 1.1 time = 175
* CHECK dout0_21 vdout0_21ck34 = 0 time = 175
* CHECK dout0_22 vdout0_22ck34 = 0 time = 175
* CHECK dout0_23 vdout0_23ck34 = 0 time = 175
* CHECK dout0_24 vdout0_24ck34 = 1.1 time = 175
* CHECK dout0_25 vdout0_25ck34 = 0 time = 175
* CHECK dout0_26 vdout0_26ck34 = 1.1 time = 175
* CHECK dout0_27 vdout0_27ck34 = 1.1 time = 175
* CHECK dout0_28 vdout0_28ck34 = 0 time = 175
* CHECK dout0_29 vdout0_29ck34 = 1.1 time = 175
* CHECK dout0_30 vdout0_30ck34 = 0 time = 175
* CHECK dout0_31 vdout0_31ck34 = 1.1 time = 175
* CHECK dout0_0 vdout0_0ck35 = 1.1 time = 180
* CHECK dout0_1 vdout0_1ck35 = 0 time = 180
* CHECK dout0_2 vdout0_2ck35 = 1.1 time = 180
* CHECK dout0_3 vdout0_3ck35 = 0 time = 180
* CHECK dout0_4 vdout0_4ck35 = 0 time = 180
* CHECK dout0_5 vdout0_5ck35 = 0 time = 180
* CHECK dout0_6 vdout0_6ck35 = 0 time = 180
* CHECK dout0_7 vdout0_7ck35 = 0 time = 180
* CHECK dout0_8 vdout0_8ck35 = 1.1 time = 180
* CHECK dout0_9 vdout0_9ck35 = 0 time = 180
* CHECK dout0_10 vdout0_10ck35 = 0 time = 180
* CHECK dout0_11 vdout0_11ck35 = 1.1 time = 180
* CHECK dout0_12 vdout0_12ck35 = 1.1 time = 180
* CHECK dout0_13 vdout0_13ck35 = 0 time = 180
* CHECK dout0_14 vdout0_14ck35 = 1.1 time = 180
* CHECK dout0_15 vdout0_15ck35 = 0 time = 180
* CHECK dout0_16 vdout0_16ck35 = 0 time = 180
* CHECK dout0_17 vdout0_17ck35 = 0 time = 180
* CHECK dout0_18 vdout0_18ck35 = 0 time = 180
* CHECK dout0_19 vdout0_19ck35 = 1.1 time = 180
* CHECK dout0_20 vdout0_20ck35 = 0 time = 180
* CHECK dout0_21 vdout0_21ck35 = 0 time = 180
* CHECK dout0_22 vdout0_22ck35 = 1.1 time = 180
* CHECK dout0_23 vdout0_23ck35 = 1.1 time = 180
* CHECK dout0_24 vdout0_24ck35 = 1.1 time = 180
* CHECK dout0_25 vdout0_25ck35 = 0 time = 180
* CHECK dout0_26 vdout0_26ck35 = 1.1 time = 180
* CHECK dout0_27 vdout0_27ck35 = 1.1 time = 180
* CHECK dout0_28 vdout0_28ck35 = 0 time = 180
* CHECK dout0_29 vdout0_29ck35 = 1.1 time = 180
* CHECK dout0_30 vdout0_30ck35 = 1.1 time = 180
* CHECK dout0_31 vdout0_31ck35 = 0 time = 180
* CHECK dout0_0 vdout0_0ck37 = 0 time = 190
* CHECK dout0_1 vdout0_1ck37 = 1.1 time = 190
* CHECK dout0_2 vdout0_2ck37 = 1.1 time = 190
* CHECK dout0_3 vdout0_3ck37 = 1.1 time = 190
* CHECK dout0_4 vdout0_4ck37 = 1.1 time = 190
* CHECK dout0_5 vdout0_5ck37 = 1.1 time = 190
* CHECK dout0_6 vdout0_6ck37 = 0 time = 190
* CHECK dout0_7 vdout0_7ck37 = 0 time = 190
* CHECK dout0_8 vdout0_8ck37 = 1.1 time = 190
* CHECK dout0_9 vdout0_9ck37 = 0 time = 190
* CHECK dout0_10 vdout0_10ck37 = 1.1 time = 190
* CHECK dout0_11 vdout0_11ck37 = 0 time = 190
* CHECK dout0_12 vdout0_12ck37 = 1.1 time = 190
* CHECK dout0_13 vdout0_13ck37 = 0 time = 190
* CHECK dout0_14 vdout0_14ck37 = 0 time = 190
* CHECK dout0_15 vdout0_15ck37 = 1.1 time = 190
* CHECK dout0_16 vdout0_16ck37 = 1.1 time = 190
* CHECK dout0_17 vdout0_17ck37 = 0 time = 190
* CHECK dout0_18 vdout0_18ck37 = 1.1 time = 190
* CHECK dout0_19 vdout0_19ck37 = 1.1 time = 190
* CHECK dout0_20 vdout0_20ck37 = 1.1 time = 190
* CHECK dout0_21 vdout0_21ck37 = 0 time = 190
* CHECK dout0_22 vdout0_22ck37 = 0 time = 190
* CHECK dout0_23 vdout0_23ck37 = 0 time = 190
* CHECK dout0_24 vdout0_24ck37 = 1.1 time = 190
* CHECK dout0_25 vdout0_25ck37 = 0 time = 190
* CHECK dout0_26 vdout0_26ck37 = 1.1 time = 190
* CHECK dout0_27 vdout0_27ck37 = 1.1 time = 190
* CHECK dout0_28 vdout0_28ck37 = 0 time = 190
* CHECK dout0_29 vdout0_29ck37 = 1.1 time = 190
* CHECK dout0_30 vdout0_30ck37 = 0 time = 190
* CHECK dout0_31 vdout0_31ck37 = 1.1 time = 190
* CHECK dout0_0 vdout0_0ck39 = 1.1 time = 200
* CHECK dout0_1 vdout0_1ck39 = 1.1 time = 200
* CHECK dout0_2 vdout0_2ck39 = 1.1 time = 200
* CHECK dout0_3 vdout0_3ck39 = 1.1 time = 200
* CHECK dout0_4 vdout0_4ck39 = 1.1 time = 200
* CHECK dout0_5 vdout0_5ck39 = 1.1 time = 200
* CHECK dout0_6 vdout0_6ck39 = 1.1 time = 200
* CHECK dout0_7 vdout0_7ck39 = 0 time = 200
* CHECK dout0_8 vdout0_8ck39 = 0 time = 200
* CHECK dout0_9 vdout0_9ck39 = 1.1 time = 200
* CHECK dout0_10 vdout0_10ck39 = 1.1 time = 200
* CHECK dout0_11 vdout0_11ck39 = 0 time = 200
* CHECK dout0_12 vdout0_12ck39 = 1.1 time = 200
* CHECK dout0_13 vdout0_13ck39 = 0 time = 200
* CHECK dout0_14 vdout0_14ck39 = 0 time = 200
* CHECK dout0_15 vdout0_15ck39 = 0 time = 200
* CHECK dout0_16 vdout0_16ck39 = 1.1 time = 200
* CHECK dout0_17 vdout0_17ck39 = 1.1 time = 200
* CHECK dout0_18 vdout0_18ck39 = 0 time = 200
* CHECK dout0_19 vdout0_19ck39 = 1.1 time = 200
* CHECK dout0_20 vdout0_20ck39 = 0 time = 200
* CHECK dout0_21 vdout0_21ck39 = 1.1 time = 200
* CHECK dout0_22 vdout0_22ck39 = 0 time = 200
* CHECK dout0_23 vdout0_23ck39 = 1.1 time = 200
* CHECK dout0_24 vdout0_24ck39 = 0 time = 200
* CHECK dout0_25 vdout0_25ck39 = 1.1 time = 200
* CHECK dout0_26 vdout0_26ck39 = 1.1 time = 200
* CHECK dout0_27 vdout0_27ck39 = 0 time = 200
* CHECK dout0_28 vdout0_28ck39 = 0 time = 200
* CHECK dout0_29 vdout0_29ck39 = 0 time = 200
* CHECK dout0_30 vdout0_30ck39 = 1.1 time = 200
* CHECK dout0_31 vdout0_31ck39 = 0 time = 200
* CHECK dout0_0 vdout0_0ck43 = 1.1 time = 220
* CHECK dout0_1 vdout0_1ck43 = 1.1 time = 220
* CHECK dout0_2 vdout0_2ck43 = 1.1 time = 220
* CHECK dout0_3 vdout0_3ck43 = 1.1 time = 220
* CHECK dout0_4 vdout0_4ck43 = 1.1 time = 220
* CHECK dout0_5 vdout0_5ck43 = 1.1 time = 220
* CHECK dout0_6 vdout0_6ck43 = 1.1 time = 220
* CHECK dout0_7 vdout0_7ck43 = 0 time = 220
* CHECK dout0_8 vdout0_8ck43 = 0 time = 220
* CHECK dout0_9 vdout0_9ck43 = 1.1 time = 220
* CHECK dout0_10 vdout0_10ck43 = 1.1 time = 220
* CHECK dout0_11 vdout0_11ck43 = 0 time = 220
* CHECK dout0_12 vdout0_12ck43 = 1.1 time = 220
* CHECK dout0_13 vdout0_13ck43 = 0 time = 220
* CHECK dout0_14 vdout0_14ck43 = 0 time = 220
* CHECK dout0_15 vdout0_15ck43 = 0 time = 220
* CHECK dout0_16 vdout0_16ck43 = 1.1 time = 220
* CHECK dout0_17 vdout0_17ck43 = 1.1 time = 220
* CHECK dout0_18 vdout0_18ck43 = 0 time = 220
* CHECK dout0_19 vdout0_19ck43 = 1.1 time = 220
* CHECK dout0_20 vdout0_20ck43 = 0 time = 220
* CHECK dout0_21 vdout0_21ck43 = 1.1 time = 220
* CHECK dout0_22 vdout0_22ck43 = 0 time = 220
* CHECK dout0_23 vdout0_23ck43 = 1.1 time = 220
* CHECK dout0_24 vdout0_24ck43 = 0 time = 220
* CHECK dout0_25 vdout0_25ck43 = 1.1 time = 220
* CHECK dout0_26 vdout0_26ck43 = 1.1 time = 220
* CHECK dout0_27 vdout0_27ck43 = 0 time = 220
* CHECK dout0_28 vdout0_28ck43 = 0 time = 220
* CHECK dout0_29 vdout0_29ck43 = 0 time = 220
* CHECK dout0_30 vdout0_30ck43 = 1.1 time = 220
* CHECK dout0_31 vdout0_31ck43 = 0 time = 220
* CHECK dout0_0 vdout0_0ck45 = 1.1 time = 230
* CHECK dout0_1 vdout0_1ck45 = 0 time = 230
* CHECK dout0_2 vdout0_2ck45 = 0 time = 230
* CHECK dout0_3 vdout0_3ck45 = 1.1 time = 230
* CHECK dout0_4 vdout0_4ck45 = 0 time = 230
* CHECK dout0_5 vdout0_5ck45 = 0 time = 230
* CHECK dout0_6 vdout0_6ck45 = 1.1 time = 230
* CHECK dout0_7 vdout0_7ck45 = 1.1 time = 230
* CHECK dout0_8 vdout0_8ck45 = 1.1 time = 230
* CHECK dout0_9 vdout0_9ck45 = 1.1 time = 230
* CHECK dout0_10 vdout0_10ck45 = 0 time = 230
* CHECK dout0_11 vdout0_11ck45 = 0 time = 230
* CHECK dout0_12 vdout0_12ck45 = 1.1 time = 230
* CHECK dout0_13 vdout0_13ck45 = 0 time = 230
* CHECK dout0_14 vdout0_14ck45 = 0 time = 230
* CHECK dout0_15 vdout0_15ck45 = 1.1 time = 230
* CHECK dout0_16 vdout0_16ck45 = 1.1 time = 230
* CHECK dout0_17 vdout0_17ck45 = 1.1 time = 230
* CHECK dout0_18 vdout0_18ck45 = 0 time = 230
* CHECK dout0_19 vdout0_19ck45 = 1.1 time = 230
* CHECK dout0_20 vdout0_20ck45 = 1.1 time = 230
* CHECK dout0_21 vdout0_21ck45 = 0 time = 230
* CHECK dout0_22 vdout0_22ck45 = 1.1 time = 230
* CHECK dout0_23 vdout0_23ck45 = 0 time = 230
* CHECK dout0_24 vdout0_24ck45 = 0 time = 230
* CHECK dout0_25 vdout0_25ck45 = 1.1 time = 230
* CHECK dout0_26 vdout0_26ck45 = 1.1 time = 230
* CHECK dout0_27 vdout0_27ck45 = 0 time = 230
* CHECK dout0_28 vdout0_28ck45 = 1.1 time = 230
* CHECK dout0_29 vdout0_29ck45 = 1.1 time = 230
* CHECK dout0_30 vdout0_30ck45 = 1.1 time = 230
* CHECK dout0_31 vdout0_31ck45 = 1.1 time = 230
* CHECK dout0_0 vdout0_0ck53 = 1.1 time = 270
* CHECK dout0_1 vdout0_1ck53 = 1.1 time = 270
* CHECK dout0_2 vdout0_2ck53 = 1.1 time = 270
* CHECK dout0_3 vdout0_3ck53 = 1.1 time = 270
* CHECK dout0_4 vdout0_4ck53 = 1.1 time = 270
* CHECK dout0_5 vdout0_5ck53 = 1.1 time = 270
* CHECK dout0_6 vdout0_6ck53 = 1.1 time = 270
* CHECK dout0_7 vdout0_7ck53 = 0 time = 270
* CHECK dout0_8 vdout0_8ck53 = 0 time = 270
* CHECK dout0_9 vdout0_9ck53 = 1.1 time = 270
* CHECK dout0_10 vdout0_10ck53 = 1.1 time = 270
* CHECK dout0_11 vdout0_11ck53 = 0 time = 270
* CHECK dout0_12 vdout0_12ck53 = 1.1 time = 270
* CHECK dout0_13 vdout0_13ck53 = 0 time = 270
* CHECK dout0_14 vdout0_14ck53 = 0 time = 270
* CHECK dout0_15 vdout0_15ck53 = 0 time = 270
* CHECK dout0_16 vdout0_16ck53 = 1.1 time = 270
* CHECK dout0_17 vdout0_17ck53 = 1.1 time = 270
* CHECK dout0_18 vdout0_18ck53 = 0 time = 270
* CHECK dout0_19 vdout0_19ck53 = 1.1 time = 270
* CHECK dout0_20 vdout0_20ck53 = 0 time = 270
* CHECK dout0_21 vdout0_21ck53 = 1.1 time = 270
* CHECK dout0_22 vdout0_22ck53 = 0 time = 270
* CHECK dout0_23 vdout0_23ck53 = 1.1 time = 270
* CHECK dout0_24 vdout0_24ck53 = 0 time = 270
* CHECK dout0_25 vdout0_25ck53 = 1.1 time = 270
* CHECK dout0_26 vdout0_26ck53 = 1.1 time = 270
* CHECK dout0_27 vdout0_27ck53 = 0 time = 270
* CHECK dout0_28 vdout0_28ck53 = 0 time = 270
* CHECK dout0_29 vdout0_29ck53 = 0 time = 270
* CHECK dout0_30 vdout0_30ck53 = 1.1 time = 270
* CHECK dout0_31 vdout0_31ck53 = 0 time = 270
* CHECK dout0_0 vdout0_0ck55 = 1.1 time = 280
* CHECK dout0_1 vdout0_1ck55 = 0 time = 280
* CHECK dout0_2 vdout0_2ck55 = 0 time = 280
* CHECK dout0_3 vdout0_3ck55 = 1.1 time = 280
* CHECK dout0_4 vdout0_4ck55 = 0 time = 280
* CHECK dout0_5 vdout0_5ck55 = 0 time = 280
* CHECK dout0_6 vdout0_6ck55 = 1.1 time = 280
* CHECK dout0_7 vdout0_7ck55 = 1.1 time = 280
* CHECK dout0_8 vdout0_8ck55 = 1.1 time = 280
* CHECK dout0_9 vdout0_9ck55 = 1.1 time = 280
* CHECK dout0_10 vdout0_10ck55 = 0 time = 280
* CHECK dout0_11 vdout0_11ck55 = 0 time = 280
* CHECK dout0_12 vdout0_12ck55 = 1.1 time = 280
* CHECK dout0_13 vdout0_13ck55 = 0 time = 280
* CHECK dout0_14 vdout0_14ck55 = 0 time = 280
* CHECK dout0_15 vdout0_15ck55 = 1.1 time = 280
* CHECK dout0_16 vdout0_16ck55 = 1.1 time = 280
* CHECK dout0_17 vdout0_17ck55 = 1.1 time = 280
* CHECK dout0_18 vdout0_18ck55 = 0 time = 280
* CHECK dout0_19 vdout0_19ck55 = 1.1 time = 280
* CHECK dout0_20 vdout0_20ck55 = 1.1 time = 280
* CHECK dout0_21 vdout0_21ck55 = 0 time = 280
* CHECK dout0_22 vdout0_22ck55 = 1.1 time = 280
* CHECK dout0_23 vdout0_23ck55 = 0 time = 280
* CHECK dout0_24 vdout0_24ck55 = 0 time = 280
* CHECK dout0_25 vdout0_25ck55 = 1.1 time = 280
* CHECK dout0_26 vdout0_26ck55 = 1.1 time = 280
* CHECK dout0_27 vdout0_27ck55 = 0 time = 280
* CHECK dout0_28 vdout0_28ck55 = 1.1 time = 280
* CHECK dout0_29 vdout0_29ck55 = 1.1 time = 280
* CHECK dout0_30 vdout0_30ck55 = 1.1 time = 280
* CHECK dout0_31 vdout0_31ck55 = 1.1 time = 280
* CHECK dout0_0 vdout0_0ck56 = 1.1 time = 285
* CHECK dout0_1 vdout0_1ck56 = 1.1 time = 285
* CHECK dout0_2 vdout0_2ck56 = 1.1 time = 285
* CHECK dout0_3 vdout0_3ck56 = 1.1 time = 285
* CHECK dout0_4 vdout0_4ck56 = 1.1 time = 285
* CHECK dout0_5 vdout0_5ck56 = 1.1 time = 285
* CHECK dout0_6 vdout0_6ck56 = 1.1 time = 285
* CHECK dout0_7 vdout0_7ck56 = 0 time = 285
* CHECK dout0_8 vdout0_8ck56 = 0 time = 285
* CHECK dout0_9 vdout0_9ck56 = 1.1 time = 285
* CHECK dout0_10 vdout0_10ck56 = 1.1 time = 285
* CHECK dout0_11 vdout0_11ck56 = 0 time = 285
* CHECK dout0_12 vdout0_12ck56 = 1.1 time = 285
* CHECK dout0_13 vdout0_13ck56 = 0 time = 285
* CHECK dout0_14 vdout0_14ck56 = 0 time = 285
* CHECK dout0_15 vdout0_15ck56 = 0 time = 285
* CHECK dout0_16 vdout0_16ck56 = 1.1 time = 285
* CHECK dout0_17 vdout0_17ck56 = 1.1 time = 285
* CHECK dout0_18 vdout0_18ck56 = 0 time = 285
* CHECK dout0_19 vdout0_19ck56 = 1.1 time = 285
* CHECK dout0_20 vdout0_20ck56 = 0 time = 285
* CHECK dout0_21 vdout0_21ck56 = 1.1 time = 285
* CHECK dout0_22 vdout0_22ck56 = 0 time = 285
* CHECK dout0_23 vdout0_23ck56 = 1.1 time = 285
* CHECK dout0_24 vdout0_24ck56 = 0 time = 285
* CHECK dout0_25 vdout0_25ck56 = 1.1 time = 285
* CHECK dout0_26 vdout0_26ck56 = 1.1 time = 285
* CHECK dout0_27 vdout0_27ck56 = 0 time = 285
* CHECK dout0_28 vdout0_28ck56 = 0 time = 285
* CHECK dout0_29 vdout0_29ck56 = 0 time = 285
* CHECK dout0_30 vdout0_30ck56 = 1.1 time = 285
* CHECK dout0_31 vdout0_31ck56 = 0 time = 285
* CHECK dout0_0 vdout0_0ck58 = 1.1 time = 295
* CHECK dout0_1 vdout0_1ck58 = 0 time = 295
* CHECK dout0_2 vdout0_2ck58 = 1.1 time = 295
* CHECK dout0_3 vdout0_3ck58 = 0 time = 295
* CHECK dout0_4 vdout0_4ck58 = 1.1 time = 295
* CHECK dout0_5 vdout0_5ck58 = 0 time = 295
* CHECK dout0_6 vdout0_6ck58 = 1.1 time = 295
* CHECK dout0_7 vdout0_7ck58 = 1.1 time = 295
* CHECK dout0_8 vdout0_8ck58 = 0 time = 295
* CHECK dout0_9 vdout0_9ck58 = 0 time = 295
* CHECK dout0_10 vdout0_10ck58 = 0 time = 295
* CHECK dout0_11 vdout0_11ck58 = 1.1 time = 295
* CHECK dout0_12 vdout0_12ck58 = 0 time = 295
* CHECK dout0_13 vdout0_13ck58 = 0 time = 295
* CHECK dout0_14 vdout0_14ck58 = 1.1 time = 295
* CHECK dout0_15 vdout0_15ck58 = 0 time = 295
* CHECK dout0_16 vdout0_16ck58 = 0 time = 295
* CHECK dout0_17 vdout0_17ck58 = 1.1 time = 295
* CHECK dout0_18 vdout0_18ck58 = 1.1 time = 295
* CHECK dout0_19 vdout0_19ck58 = 0 time = 295
* CHECK dout0_20 vdout0_20ck58 = 0 time = 295
* CHECK dout0_21 vdout0_21ck58 = 0 time = 295
* CHECK dout0_22 vdout0_22ck58 = 0 time = 295
* CHECK dout0_23 vdout0_23ck58 = 0 time = 295
* CHECK dout0_24 vdout0_24ck58 = 0 time = 295
* CHECK dout0_25 vdout0_25ck58 = 1.1 time = 295
* CHECK dout0_26 vdout0_26ck58 = 1.1 time = 295
* CHECK dout0_27 vdout0_27ck58 = 1.1 time = 295
* CHECK dout0_28 vdout0_28ck58 = 0 time = 295
* CHECK dout0_29 vdout0_29ck58 = 0 time = 295
* CHECK dout0_30 vdout0_30ck58 = 1.1 time = 295
* CHECK dout0_31 vdout0_31ck58 = 0 time = 295
* CHECK dout0_0 vdout0_0ck59 = 1.1 time = 300
* CHECK dout0_1 vdout0_1ck59 = 1.1 time = 300
* CHECK dout0_2 vdout0_2ck59 = 1.1 time = 300
* CHECK dout0_3 vdout0_3ck59 = 1.1 time = 300
* CHECK dout0_4 vdout0_4ck59 = 0 time = 300
* CHECK dout0_5 vdout0_5ck59 = 1.1 time = 300
* CHECK dout0_6 vdout0_6ck59 = 0 time = 300
* CHECK dout0_7 vdout0_7ck59 = 1.1 time = 300
* CHECK dout0_8 vdout0_8ck59 = 1.1 time = 300
* CHECK dout0_9 vdout0_9ck59 = 0 time = 300
* CHECK dout0_10 vdout0_10ck59 = 0 time = 300
* CHECK dout0_11 vdout0_11ck59 = 0 time = 300
* CHECK dout0_12 vdout0_12ck59 = 1.1 time = 300
* CHECK dout0_13 vdout0_13ck59 = 0 time = 300
* CHECK dout0_14 vdout0_14ck59 = 1.1 time = 300
* CHECK dout0_15 vdout0_15ck59 = 1.1 time = 300
* CHECK dout0_16 vdout0_16ck59 = 0 time = 300
* CHECK dout0_17 vdout0_17ck59 = 0 time = 300
* CHECK dout0_18 vdout0_18ck59 = 1.1 time = 300
* CHECK dout0_19 vdout0_19ck59 = 0 time = 300
* CHECK dout0_20 vdout0_20ck59 = 0 time = 300
* CHECK dout0_21 vdout0_21ck59 = 1.1 time = 300
* CHECK dout0_22 vdout0_22ck59 = 1.1 time = 300
* CHECK dout0_23 vdout0_23ck59 = 1.1 time = 300
* CHECK dout0_24 vdout0_24ck59 = 1.1 time = 300
* CHECK dout0_25 vdout0_25ck59 = 1.1 time = 300
* CHECK dout0_26 vdout0_26ck59 = 1.1 time = 300
* CHECK dout0_27 vdout0_27ck59 = 0 time = 300
* CHECK dout0_28 vdout0_28ck59 = 0 time = 300
* CHECK dout0_29 vdout0_29ck59 = 0 time = 300
* CHECK dout0_30 vdout0_30ck59 = 1.1 time = 300
* CHECK dout0_31 vdout0_31ck59 = 1.1 time = 300
* CHECK dout0_0 vdout0_0ck60 = 1.1 time = 305
* CHECK dout0_1 vdout0_1ck60 = 1.1 time = 305
* CHECK dout0_2 vdout0_2ck60 = 1.1 time = 305
* CHECK dout0_3 vdout0_3ck60 = 1.1 time = 305
* CHECK dout0_4 vdout0_4ck60 = 0 time = 305
* CHECK dout0_5 vdout0_5ck60 = 1.1 time = 305
* CHECK dout0_6 vdout0_6ck60 = 0 time = 305
* CHECK dout0_7 vdout0_7ck60 = 1.1 time = 305
* CHECK dout0_8 vdout0_8ck60 = 1.1 time = 305
* CHECK dout0_9 vdout0_9ck60 = 0 time = 305
* CHECK dout0_10 vdout0_10ck60 = 0 time = 305
* CHECK dout0_11 vdout0_11ck60 = 0 time = 305
* CHECK dout0_12 vdout0_12ck60 = 1.1 time = 305
* CHECK dout0_13 vdout0_13ck60 = 0 time = 305
* CHECK dout0_14 vdout0_14ck60 = 1.1 time = 305
* CHECK dout0_15 vdout0_15ck60 = 1.1 time = 305
* CHECK dout0_16 vdout0_16ck60 = 0 time = 305
* CHECK dout0_17 vdout0_17ck60 = 0 time = 305
* CHECK dout0_18 vdout0_18ck60 = 1.1 time = 305
* CHECK dout0_19 vdout0_19ck60 = 0 time = 305
* CHECK dout0_20 vdout0_20ck60 = 0 time = 305
* CHECK dout0_21 vdout0_21ck60 = 1.1 time = 305
* CHECK dout0_22 vdout0_22ck60 = 1.1 time = 305
* CHECK dout0_23 vdout0_23ck60 = 1.1 time = 305
* CHECK dout0_24 vdout0_24ck60 = 1.1 time = 305
* CHECK dout0_25 vdout0_25ck60 = 1.1 time = 305
* CHECK dout0_26 vdout0_26ck60 = 1.1 time = 305
* CHECK dout0_27 vdout0_27ck60 = 0 time = 305
* CHECK dout0_28 vdout0_28ck60 = 0 time = 305
* CHECK dout0_29 vdout0_29ck60 = 0 time = 305
* CHECK dout0_30 vdout0_30ck60 = 1.1 time = 305
* CHECK dout0_31 vdout0_31ck60 = 1.1 time = 305
* CHECK dout0_0 vdout0_0ck63 = 1.1 time = 320
* CHECK dout0_1 vdout0_1ck63 = 0 time = 320
* CHECK dout0_2 vdout0_2ck63 = 0 time = 320
* CHECK dout0_3 vdout0_3ck63 = 0 time = 320
* CHECK dout0_4 vdout0_4ck63 = 1.1 time = 320
* CHECK dout0_5 vdout0_5ck63 = 1.1 time = 320
* CHECK dout0_6 vdout0_6ck63 = 0 time = 320
* CHECK dout0_7 vdout0_7ck63 = 1.1 time = 320
* CHECK dout0_8 vdout0_8ck63 = 0 time = 320
* CHECK dout0_9 vdout0_9ck63 = 0 time = 320
* CHECK dout0_10 vdout0_10ck63 = 0 time = 320
* CHECK dout0_11 vdout0_11ck63 = 1.1 time = 320
* CHECK dout0_12 vdout0_12ck63 = 0 time = 320
* CHECK dout0_13 vdout0_13ck63 = 0 time = 320
* CHECK dout0_14 vdout0_14ck63 = 0 time = 320
* CHECK dout0_15 vdout0_15ck63 = 0 time = 320
* CHECK dout0_16 vdout0_16ck63 = 1.1 time = 320
* CHECK dout0_17 vdout0_17ck63 = 0 time = 320
* CHECK dout0_18 vdout0_18ck63 = 1.1 time = 320
* CHECK dout0_19 vdout0_19ck63 = 1.1 time = 320
* CHECK dout0_20 vdout0_20ck63 = 1.1 time = 320
* CHECK dout0_21 vdout0_21ck63 = 1.1 time = 320
* CHECK dout0_22 vdout0_22ck63 = 0 time = 320
* CHECK dout0_23 vdout0_23ck63 = 0 time = 320
* CHECK dout0_24 vdout0_24ck63 = 1.1 time = 320
* CHECK dout0_25 vdout0_25ck63 = 0 time = 320
* CHECK dout0_26 vdout0_26ck63 = 0 time = 320
* CHECK dout0_27 vdout0_27ck63 = 1.1 time = 320
* CHECK dout0_28 vdout0_28ck63 = 0 time = 320
* CHECK dout0_29 vdout0_29ck63 = 1.1 time = 320
* CHECK dout0_30 vdout0_30ck63 = 0 time = 320
* CHECK dout0_31 vdout0_31ck63 = 0 time = 320
* CHECK dout0_0 vdout0_0ck67 = 0 time = 340
* CHECK dout0_1 vdout0_1ck67 = 1.1 time = 340
* CHECK dout0_2 vdout0_2ck67 = 1.1 time = 340
* CHECK dout0_3 vdout0_3ck67 = 1.1 time = 340
* CHECK dout0_4 vdout0_4ck67 = 1.1 time = 340
* CHECK dout0_5 vdout0_5ck67 = 1.1 time = 340
* CHECK dout0_6 vdout0_6ck67 = 0 time = 340
* CHECK dout0_7 vdout0_7ck67 = 0 time = 340
* CHECK dout0_8 vdout0_8ck67 = 1.1 time = 340
* CHECK dout0_9 vdout0_9ck67 = 0 time = 340
* CHECK dout0_10 vdout0_10ck67 = 1.1 time = 340
* CHECK dout0_11 vdout0_11ck67 = 0 time = 340
* CHECK dout0_12 vdout0_12ck67 = 0 time = 340
* CHECK dout0_13 vdout0_13ck67 = 1.1 time = 340
* CHECK dout0_14 vdout0_14ck67 = 1.1 time = 340
* CHECK dout0_15 vdout0_15ck67 = 0 time = 340
* CHECK dout0_16 vdout0_16ck67 = 1.1 time = 340
* CHECK dout0_17 vdout0_17ck67 = 0 time = 340
* CHECK dout0_18 vdout0_18ck67 = 1.1 time = 340
* CHECK dout0_19 vdout0_19ck67 = 1.1 time = 340
* CHECK dout0_20 vdout0_20ck67 = 0 time = 340
* CHECK dout0_21 vdout0_21ck67 = 0 time = 340
* CHECK dout0_22 vdout0_22ck67 = 0 time = 340
* CHECK dout0_23 vdout0_23ck67 = 0 time = 340
* CHECK dout0_24 vdout0_24ck67 = 1.1 time = 340
* CHECK dout0_25 vdout0_25ck67 = 0 time = 340
* CHECK dout0_26 vdout0_26ck67 = 0 time = 340
* CHECK dout0_27 vdout0_27ck67 = 1.1 time = 340
* CHECK dout0_28 vdout0_28ck67 = 1.1 time = 340
* CHECK dout0_29 vdout0_29ck67 = 0 time = 340
* CHECK dout0_30 vdout0_30ck67 = 1.1 time = 340
* CHECK dout0_31 vdout0_31ck67 = 1.1 time = 340
* CHECK dout0_0 vdout0_0ck68 = 1.1 time = 345
* CHECK dout0_1 vdout0_1ck68 = 0 time = 345
* CHECK dout0_2 vdout0_2ck68 = 0 time = 345
* CHECK dout0_3 vdout0_3ck68 = 0 time = 345
* CHECK dout0_4 vdout0_4ck68 = 1.1 time = 345
* CHECK dout0_5 vdout0_5ck68 = 1.1 time = 345
* CHECK dout0_6 vdout0_6ck68 = 0 time = 345
* CHECK dout0_7 vdout0_7ck68 = 1.1 time = 345
* CHECK dout0_8 vdout0_8ck68 = 0 time = 345
* CHECK dout0_9 vdout0_9ck68 = 0 time = 345
* CHECK dout0_10 vdout0_10ck68 = 0 time = 345
* CHECK dout0_11 vdout0_11ck68 = 1.1 time = 345
* CHECK dout0_12 vdout0_12ck68 = 0 time = 345
* CHECK dout0_13 vdout0_13ck68 = 0 time = 345
* CHECK dout0_14 vdout0_14ck68 = 0 time = 345
* CHECK dout0_15 vdout0_15ck68 = 0 time = 345
* CHECK dout0_16 vdout0_16ck68 = 1.1 time = 345
* CHECK dout0_17 vdout0_17ck68 = 0 time = 345
* CHECK dout0_18 vdout0_18ck68 = 1.1 time = 345
* CHECK dout0_19 vdout0_19ck68 = 1.1 time = 345
* CHECK dout0_20 vdout0_20ck68 = 1.1 time = 345
* CHECK dout0_21 vdout0_21ck68 = 1.1 time = 345
* CHECK dout0_22 vdout0_22ck68 = 0 time = 345
* CHECK dout0_23 vdout0_23ck68 = 0 time = 345
* CHECK dout0_24 vdout0_24ck68 = 1.1 time = 345
* CHECK dout0_25 vdout0_25ck68 = 0 time = 345
* CHECK dout0_26 vdout0_26ck68 = 0 time = 345
* CHECK dout0_27 vdout0_27ck68 = 1.1 time = 345
* CHECK dout0_28 vdout0_28ck68 = 0 time = 345
* CHECK dout0_29 vdout0_29ck68 = 1.1 time = 345
* CHECK dout0_30 vdout0_30ck68 = 0 time = 345
* CHECK dout0_31 vdout0_31ck68 = 0 time = 345
* CHECK dout0_0 vdout0_0ck70 = 1.1 time = 355
* CHECK dout0_1 vdout0_1ck70 = 0 time = 355
* CHECK dout0_2 vdout0_2ck70 = 1.1 time = 355
* CHECK dout0_3 vdout0_3ck70 = 1.1 time = 355
* CHECK dout0_4 vdout0_4ck70 = 1.1 time = 355
* CHECK dout0_5 vdout0_5ck70 = 0 time = 355
* CHECK dout0_6 vdout0_6ck70 = 0 time = 355
* CHECK dout0_7 vdout0_7ck70 = 1.1 time = 355
* CHECK dout0_8 vdout0_8ck70 = 0 time = 355
* CHECK dout0_9 vdout0_9ck70 = 0 time = 355
* CHECK dout0_10 vdout0_10ck70 = 1.1 time = 355
* CHECK dout0_11 vdout0_11ck70 = 1.1 time = 355
* CHECK dout0_12 vdout0_12ck70 = 1.1 time = 355
* CHECK dout0_13 vdout0_13ck70 = 0 time = 355
* CHECK dout0_14 vdout0_14ck70 = 0 time = 355
* CHECK dout0_15 vdout0_15ck70 = 1.1 time = 355
* CHECK dout0_16 vdout0_16ck70 = 0 time = 355
* CHECK dout0_17 vdout0_17ck70 = 1.1 time = 355
* CHECK dout0_18 vdout0_18ck70 = 1.1 time = 355
* CHECK dout0_19 vdout0_19ck70 = 1.1 time = 355
* CHECK dout0_20 vdout0_20ck70 = 0 time = 355
* CHECK dout0_21 vdout0_21ck70 = 0 time = 355
* CHECK dout0_22 vdout0_22ck70 = 0 time = 355
* CHECK dout0_23 vdout0_23ck70 = 1.1 time = 355
* CHECK dout0_24 vdout0_24ck70 = 1.1 time = 355
* CHECK dout0_25 vdout0_25ck70 = 0 time = 355
* CHECK dout0_26 vdout0_26ck70 = 0 time = 355
* CHECK dout0_27 vdout0_27ck70 = 0 time = 355
* CHECK dout0_28 vdout0_28ck70 = 0 time = 355
* CHECK dout0_29 vdout0_29ck70 = 1.1 time = 355
* CHECK dout0_30 vdout0_30ck70 = 1.1 time = 355
* CHECK dout0_31 vdout0_31ck70 = 0 time = 355
* CHECK dout0_0 vdout0_0ck71 = 1.1 time = 360
* CHECK dout0_1 vdout0_1ck71 = 1.1 time = 360
* CHECK dout0_2 vdout0_2ck71 = 1.1 time = 360
* CHECK dout0_3 vdout0_3ck71 = 1.1 time = 360
* CHECK dout0_4 vdout0_4ck71 = 1.1 time = 360
* CHECK dout0_5 vdout0_5ck71 = 1.1 time = 360
* CHECK dout0_6 vdout0_6ck71 = 1.1 time = 360
* CHECK dout0_7 vdout0_7ck71 = 0 time = 360
* CHECK dout0_8 vdout0_8ck71 = 0 time = 360
* CHECK dout0_9 vdout0_9ck71 = 1.1 time = 360
* CHECK dout0_10 vdout0_10ck71 = 1.1 time = 360
* CHECK dout0_11 vdout0_11ck71 = 0 time = 360
* CHECK dout0_12 vdout0_12ck71 = 1.1 time = 360
* CHECK dout0_13 vdout0_13ck71 = 0 time = 360
* CHECK dout0_14 vdout0_14ck71 = 0 time = 360
* CHECK dout0_15 vdout0_15ck71 = 0 time = 360
* CHECK dout0_16 vdout0_16ck71 = 1.1 time = 360
* CHECK dout0_17 vdout0_17ck71 = 1.1 time = 360
* CHECK dout0_18 vdout0_18ck71 = 0 time = 360
* CHECK dout0_19 vdout0_19ck71 = 1.1 time = 360
* CHECK dout0_20 vdout0_20ck71 = 0 time = 360
* CHECK dout0_21 vdout0_21ck71 = 1.1 time = 360
* CHECK dout0_22 vdout0_22ck71 = 0 time = 360
* CHECK dout0_23 vdout0_23ck71 = 1.1 time = 360
* CHECK dout0_24 vdout0_24ck71 = 0 time = 360
* CHECK dout0_25 vdout0_25ck71 = 1.1 time = 360
* CHECK dout0_26 vdout0_26ck71 = 1.1 time = 360
* CHECK dout0_27 vdout0_27ck71 = 0 time = 360
* CHECK dout0_28 vdout0_28ck71 = 0 time = 360
* CHECK dout0_29 vdout0_29ck71 = 0 time = 360
* CHECK dout0_30 vdout0_30ck71 = 1.1 time = 360
* CHECK dout0_31 vdout0_31ck71 = 0 time = 360
* CHECK dout0_0 vdout0_0ck72 = 1.1 time = 365
* CHECK dout0_1 vdout0_1ck72 = 0 time = 365
* CHECK dout0_2 vdout0_2ck72 = 1.1 time = 365
* CHECK dout0_3 vdout0_3ck72 = 1.1 time = 365
* CHECK dout0_4 vdout0_4ck72 = 1.1 time = 365
* CHECK dout0_5 vdout0_5ck72 = 0 time = 365
* CHECK dout0_6 vdout0_6ck72 = 0 time = 365
* CHECK dout0_7 vdout0_7ck72 = 1.1 time = 365
* CHECK dout0_8 vdout0_8ck72 = 0 time = 365
* CHECK dout0_9 vdout0_9ck72 = 0 time = 365
* CHECK dout0_10 vdout0_10ck72 = 1.1 time = 365
* CHECK dout0_11 vdout0_11ck72 = 1.1 time = 365
* CHECK dout0_12 vdout0_12ck72 = 1.1 time = 365
* CHECK dout0_13 vdout0_13ck72 = 0 time = 365
* CHECK dout0_14 vdout0_14ck72 = 0 time = 365
* CHECK dout0_15 vdout0_15ck72 = 1.1 time = 365
* CHECK dout0_16 vdout0_16ck72 = 0 time = 365
* CHECK dout0_17 vdout0_17ck72 = 1.1 time = 365
* CHECK dout0_18 vdout0_18ck72 = 1.1 time = 365
* CHECK dout0_19 vdout0_19ck72 = 1.1 time = 365
* CHECK dout0_20 vdout0_20ck72 = 0 time = 365
* CHECK dout0_21 vdout0_21ck72 = 0 time = 365
* CHECK dout0_22 vdout0_22ck72 = 0 time = 365
* CHECK dout0_23 vdout0_23ck72 = 1.1 time = 365
* CHECK dout0_24 vdout0_24ck72 = 1.1 time = 365
* CHECK dout0_25 vdout0_25ck72 = 0 time = 365
* CHECK dout0_26 vdout0_26ck72 = 0 time = 365
* CHECK dout0_27 vdout0_27ck72 = 0 time = 365
* CHECK dout0_28 vdout0_28ck72 = 0 time = 365
* CHECK dout0_29 vdout0_29ck72 = 1.1 time = 365
* CHECK dout0_30 vdout0_30ck72 = 1.1 time = 365
* CHECK dout0_31 vdout0_31ck72 = 0 time = 365
* CHECK dout0_0 vdout0_0ck81 = 0 time = 410
* CHECK dout0_1 vdout0_1ck81 = 0 time = 410
* CHECK dout0_2 vdout0_2ck81 = 0 time = 410
* CHECK dout0_3 vdout0_3ck81 = 0 time = 410
* CHECK dout0_4 vdout0_4ck81 = 0 time = 410
* CHECK dout0_5 vdout0_5ck81 = 0 time = 410
* CHECK dout0_6 vdout0_6ck81 = 0 time = 410
* CHECK dout0_7 vdout0_7ck81 = 1.1 time = 410
* CHECK dout0_8 vdout0_8ck81 = 0 time = 410
* CHECK dout0_9 vdout0_9ck81 = 1.1 time = 410
* CHECK dout0_10 vdout0_10ck81 = 1.1 time = 410
* CHECK dout0_11 vdout0_11ck81 = 0 time = 410
* CHECK dout0_12 vdout0_12ck81 = 0 time = 410
* CHECK dout0_13 vdout0_13ck81 = 1.1 time = 410
* CHECK dout0_14 vdout0_14ck81 = 1.1 time = 410
* CHECK dout0_15 vdout0_15ck81 = 1.1 time = 410
* CHECK dout0_16 vdout0_16ck81 = 0 time = 410
* CHECK dout0_17 vdout0_17ck81 = 1.1 time = 410
* CHECK dout0_18 vdout0_18ck81 = 1.1 time = 410
* CHECK dout0_19 vdout0_19ck81 = 1.1 time = 410
* CHECK dout0_20 vdout0_20ck81 = 1.1 time = 410
* CHECK dout0_21 vdout0_21ck81 = 0 time = 410
* CHECK dout0_22 vdout0_22ck81 = 0 time = 410
* CHECK dout0_23 vdout0_23ck81 = 0 time = 410
* CHECK dout0_24 vdout0_24ck81 = 1.1 time = 410
* CHECK dout0_25 vdout0_25ck81 = 1.1 time = 410
* CHECK dout0_26 vdout0_26ck81 = 1.1 time = 410
* CHECK dout0_27 vdout0_27ck81 = 1.1 time = 410
* CHECK dout0_28 vdout0_28ck81 = 0 time = 410
* CHECK dout0_29 vdout0_29ck81 = 0 time = 410
* CHECK dout0_30 vdout0_30ck81 = 1.1 time = 410
* CHECK dout0_31 vdout0_31ck81 = 1.1 time = 410
* CHECK dout0_0 vdout0_0ck82 = 1.1 time = 415
* CHECK dout0_1 vdout0_1ck82 = 0 time = 415
* CHECK dout0_2 vdout0_2ck82 = 1.1 time = 415
* CHECK dout0_3 vdout0_3ck82 = 1.1 time = 415
* CHECK dout0_4 vdout0_4ck82 = 1.1 time = 415
* CHECK dout0_5 vdout0_5ck82 = 0 time = 415
* CHECK dout0_6 vdout0_6ck82 = 0 time = 415
* CHECK dout0_7 vdout0_7ck82 = 1.1 time = 415
* CHECK dout0_8 vdout0_8ck82 = 0 time = 415
* CHECK dout0_9 vdout0_9ck82 = 0 time = 415
* CHECK dout0_10 vdout0_10ck82 = 1.1 time = 415
* CHECK dout0_11 vdout0_11ck82 = 1.1 time = 415
* CHECK dout0_12 vdout0_12ck82 = 1.1 time = 415
* CHECK dout0_13 vdout0_13ck82 = 0 time = 415
* CHECK dout0_14 vdout0_14ck82 = 0 time = 415
* CHECK dout0_15 vdout0_15ck82 = 1.1 time = 415
* CHECK dout0_16 vdout0_16ck82 = 0 time = 415
* CHECK dout0_17 vdout0_17ck82 = 1.1 time = 415
* CHECK dout0_18 vdout0_18ck82 = 1.1 time = 415
* CHECK dout0_19 vdout0_19ck82 = 1.1 time = 415
* CHECK dout0_20 vdout0_20ck82 = 0 time = 415
* CHECK dout0_21 vdout0_21ck82 = 0 time = 415
* CHECK dout0_22 vdout0_22ck82 = 0 time = 415
* CHECK dout0_23 vdout0_23ck82 = 1.1 time = 415
* CHECK dout0_24 vdout0_24ck82 = 1.1 time = 415
* CHECK dout0_25 vdout0_25ck82 = 0 time = 415
* CHECK dout0_26 vdout0_26ck82 = 0 time = 415
* CHECK dout0_27 vdout0_27ck82 = 0 time = 415
* CHECK dout0_28 vdout0_28ck82 = 0 time = 415
* CHECK dout0_29 vdout0_29ck82 = 1.1 time = 415
* CHECK dout0_30 vdout0_30ck82 = 1.1 time = 415
* CHECK dout0_31 vdout0_31ck82 = 0 time = 415
* CHECK dout0_0 vdout0_0ck85 = 0 time = 430
* CHECK dout0_1 vdout0_1ck85 = 0 time = 430
* CHECK dout0_2 vdout0_2ck85 = 0 time = 430
* CHECK dout0_3 vdout0_3ck85 = 0 time = 430
* CHECK dout0_4 vdout0_4ck85 = 0 time = 430
* CHECK dout0_5 vdout0_5ck85 = 0 time = 430
* CHECK dout0_6 vdout0_6ck85 = 0 time = 430
* CHECK dout0_7 vdout0_7ck85 = 1.1 time = 430
* CHECK dout0_8 vdout0_8ck85 = 0 time = 430
* CHECK dout0_9 vdout0_9ck85 = 1.1 time = 430
* CHECK dout0_10 vdout0_10ck85 = 1.1 time = 430
* CHECK dout0_11 vdout0_11ck85 = 0 time = 430
* CHECK dout0_12 vdout0_12ck85 = 0 time = 430
* CHECK dout0_13 vdout0_13ck85 = 1.1 time = 430
* CHECK dout0_14 vdout0_14ck85 = 1.1 time = 430
* CHECK dout0_15 vdout0_15ck85 = 1.1 time = 430
* CHECK dout0_16 vdout0_16ck85 = 0 time = 430
* CHECK dout0_17 vdout0_17ck85 = 1.1 time = 430
* CHECK dout0_18 vdout0_18ck85 = 1.1 time = 430
* CHECK dout0_19 vdout0_19ck85 = 1.1 time = 430
* CHECK dout0_20 vdout0_20ck85 = 1.1 time = 430
* CHECK dout0_21 vdout0_21ck85 = 0 time = 430
* CHECK dout0_22 vdout0_22ck85 = 0 time = 430
* CHECK dout0_23 vdout0_23ck85 = 0 time = 430
* CHECK dout0_24 vdout0_24ck85 = 1.1 time = 430
* CHECK dout0_25 vdout0_25ck85 = 1.1 time = 430
* CHECK dout0_26 vdout0_26ck85 = 1.1 time = 430
* CHECK dout0_27 vdout0_27ck85 = 1.1 time = 430
* CHECK dout0_28 vdout0_28ck85 = 0 time = 430
* CHECK dout0_29 vdout0_29ck85 = 0 time = 430
* CHECK dout0_30 vdout0_30ck85 = 1.1 time = 430
* CHECK dout0_31 vdout0_31ck85 = 1.1 time = 430
* CHECK dout0_0 vdout0_0ck87 = 0 time = 440
* CHECK dout0_1 vdout0_1ck87 = 0 time = 440
* CHECK dout0_2 vdout0_2ck87 = 0 time = 440
* CHECK dout0_3 vdout0_3ck87 = 0 time = 440
* CHECK dout0_4 vdout0_4ck87 = 0 time = 440
* CHECK dout0_5 vdout0_5ck87 = 0 time = 440
* CHECK dout0_6 vdout0_6ck87 = 0 time = 440
* CHECK dout0_7 vdout0_7ck87 = 1.1 time = 440
* CHECK dout0_8 vdout0_8ck87 = 0 time = 440
* CHECK dout0_9 vdout0_9ck87 = 1.1 time = 440
* CHECK dout0_10 vdout0_10ck87 = 1.1 time = 440
* CHECK dout0_11 vdout0_11ck87 = 0 time = 440
* CHECK dout0_12 vdout0_12ck87 = 0 time = 440
* CHECK dout0_13 vdout0_13ck87 = 1.1 time = 440
* CHECK dout0_14 vdout0_14ck87 = 1.1 time = 440
* CHECK dout0_15 vdout0_15ck87 = 1.1 time = 440
* CHECK dout0_16 vdout0_16ck87 = 0 time = 440
* CHECK dout0_17 vdout0_17ck87 = 1.1 time = 440
* CHECK dout0_18 vdout0_18ck87 = 1.1 time = 440
* CHECK dout0_19 vdout0_19ck87 = 1.1 time = 440
* CHECK dout0_20 vdout0_20ck87 = 1.1 time = 440
* CHECK dout0_21 vdout0_21ck87 = 0 time = 440
* CHECK dout0_22 vdout0_22ck87 = 0 time = 440
* CHECK dout0_23 vdout0_23ck87 = 0 time = 440
* CHECK dout0_24 vdout0_24ck87 = 1.1 time = 440
* CHECK dout0_25 vdout0_25ck87 = 1.1 time = 440
* CHECK dout0_26 vdout0_26ck87 = 1.1 time = 440
* CHECK dout0_27 vdout0_27ck87 = 1.1 time = 440
* CHECK dout0_28 vdout0_28ck87 = 0 time = 440
* CHECK dout0_29 vdout0_29ck87 = 0 time = 440
* CHECK dout0_30 vdout0_30ck87 = 1.1 time = 440
* CHECK dout0_31 vdout0_31ck87 = 1.1 time = 440
* CHECK dout0_0 vdout0_0ck89 = 1.1 time = 450
* CHECK dout0_1 vdout0_1ck89 = 0 time = 450
* CHECK dout0_2 vdout0_2ck89 = 0 time = 450
* CHECK dout0_3 vdout0_3ck89 = 1.1 time = 450
* CHECK dout0_4 vdout0_4ck89 = 0 time = 450
* CHECK dout0_5 vdout0_5ck89 = 0 time = 450
* CHECK dout0_6 vdout0_6ck89 = 1.1 time = 450
* CHECK dout0_7 vdout0_7ck89 = 1.1 time = 450
* CHECK dout0_8 vdout0_8ck89 = 1.1 time = 450
* CHECK dout0_9 vdout0_9ck89 = 1.1 time = 450
* CHECK dout0_10 vdout0_10ck89 = 0 time = 450
* CHECK dout0_11 vdout0_11ck89 = 0 time = 450
* CHECK dout0_12 vdout0_12ck89 = 1.1 time = 450
* CHECK dout0_13 vdout0_13ck89 = 0 time = 450
* CHECK dout0_14 vdout0_14ck89 = 0 time = 450
* CHECK dout0_15 vdout0_15ck89 = 1.1 time = 450
* CHECK dout0_16 vdout0_16ck89 = 1.1 time = 450
* CHECK dout0_17 vdout0_17ck89 = 1.1 time = 450
* CHECK dout0_18 vdout0_18ck89 = 0 time = 450
* CHECK dout0_19 vdout0_19ck89 = 1.1 time = 450
* CHECK dout0_20 vdout0_20ck89 = 1.1 time = 450
* CHECK dout0_21 vdout0_21ck89 = 0 time = 450
* CHECK dout0_22 vdout0_22ck89 = 1.1 time = 450
* CHECK dout0_23 vdout0_23ck89 = 0 time = 450
* CHECK dout0_24 vdout0_24ck89 = 0 time = 450
* CHECK dout0_25 vdout0_25ck89 = 1.1 time = 450
* CHECK dout0_26 vdout0_26ck89 = 1.1 time = 450
* CHECK dout0_27 vdout0_27ck89 = 0 time = 450
* CHECK dout0_28 vdout0_28ck89 = 1.1 time = 450
* CHECK dout0_29 vdout0_29ck89 = 1.1 time = 450
* CHECK dout0_30 vdout0_30ck89 = 1.1 time = 450
* CHECK dout0_31 vdout0_31ck89 = 1.1 time = 450
* CHECK dout0_0 vdout0_0ck90 = 0 time = 455
* CHECK dout0_1 vdout0_1ck90 = 0 time = 455
* CHECK dout0_2 vdout0_2ck90 = 0 time = 455
* CHECK dout0_3 vdout0_3ck90 = 0 time = 455
* CHECK dout0_4 vdout0_4ck90 = 0 time = 455
* CHECK dout0_5 vdout0_5ck90 = 0 time = 455
* CHECK dout0_6 vdout0_6ck90 = 0 time = 455
* CHECK dout0_7 vdout0_7ck90 = 1.1 time = 455
* CHECK dout0_8 vdout0_8ck90 = 0 time = 455
* CHECK dout0_9 vdout0_9ck90 = 1.1 time = 455
* CHECK dout0_10 vdout0_10ck90 = 1.1 time = 455
* CHECK dout0_11 vdout0_11ck90 = 0 time = 455
* CHECK dout0_12 vdout0_12ck90 = 0 time = 455
* CHECK dout0_13 vdout0_13ck90 = 1.1 time = 455
* CHECK dout0_14 vdout0_14ck90 = 1.1 time = 455
* CHECK dout0_15 vdout0_15ck90 = 1.1 time = 455
* CHECK dout0_16 vdout0_16ck90 = 0 time = 455
* CHECK dout0_17 vdout0_17ck90 = 1.1 time = 455
* CHECK dout0_18 vdout0_18ck90 = 1.1 time = 455
* CHECK dout0_19 vdout0_19ck90 = 1.1 time = 455
* CHECK dout0_20 vdout0_20ck90 = 1.1 time = 455
* CHECK dout0_21 vdout0_21ck90 = 0 time = 455
* CHECK dout0_22 vdout0_22ck90 = 0 time = 455
* CHECK dout0_23 vdout0_23ck90 = 0 time = 455
* CHECK dout0_24 vdout0_24ck90 = 1.1 time = 455
* CHECK dout0_25 vdout0_25ck90 = 1.1 time = 455
* CHECK dout0_26 vdout0_26ck90 = 1.1 time = 455
* CHECK dout0_27 vdout0_27ck90 = 1.1 time = 455
* CHECK dout0_28 vdout0_28ck90 = 0 time = 455
* CHECK dout0_29 vdout0_29ck90 = 0 time = 455
* CHECK dout0_30 vdout0_30ck90 = 1.1 time = 455
* CHECK dout0_31 vdout0_31ck90 = 1.1 time = 455
* CHECK dout0_0 vdout0_0ck91 = 0 time = 460
* CHECK dout0_1 vdout0_1ck91 = 0 time = 460
* CHECK dout0_2 vdout0_2ck91 = 0 time = 460
* CHECK dout0_3 vdout0_3ck91 = 1.1 time = 460
* CHECK dout0_4 vdout0_4ck91 = 1.1 time = 460
* CHECK dout0_5 vdout0_5ck91 = 1.1 time = 460
* CHECK dout0_6 vdout0_6ck91 = 0 time = 460
* CHECK dout0_7 vdout0_7ck91 = 0 time = 460
* CHECK dout0_8 vdout0_8ck91 = 1.1 time = 460
* CHECK dout0_9 vdout0_9ck91 = 1.1 time = 460
* CHECK dout0_10 vdout0_10ck91 = 0 time = 460
* CHECK dout0_11 vdout0_11ck91 = 0 time = 460
* CHECK dout0_12 vdout0_12ck91 = 1.1 time = 460
* CHECK dout0_13 vdout0_13ck91 = 0 time = 460
* CHECK dout0_14 vdout0_14ck91 = 1.1 time = 460
* CHECK dout0_15 vdout0_15ck91 = 1.1 time = 460
* CHECK dout0_16 vdout0_16ck91 = 1.1 time = 460
* CHECK dout0_17 vdout0_17ck91 = 0 time = 460
* CHECK dout0_18 vdout0_18ck91 = 1.1 time = 460
* CHECK dout0_19 vdout0_19ck91 = 0 time = 460
* CHECK dout0_20 vdout0_20ck91 = 0 time = 460
* CHECK dout0_21 vdout0_21ck91 = 0 time = 460
* CHECK dout0_22 vdout0_22ck91 = 0 time = 460
* CHECK dout0_23 vdout0_23ck91 = 1.1 time = 460
* CHECK dout0_24 vdout0_24ck91 = 1.1 time = 460
* CHECK dout0_25 vdout0_25ck91 = 1.1 time = 460
* CHECK dout0_26 vdout0_26ck91 = 0 time = 460
* CHECK dout0_27 vdout0_27ck91 = 0 time = 460
* CHECK dout0_28 vdout0_28ck91 = 1.1 time = 460
* CHECK dout0_29 vdout0_29ck91 = 0 time = 460
* CHECK dout0_30 vdout0_30ck91 = 1.1 time = 460
* CHECK dout0_31 vdout0_31ck91 = 1.1 time = 460
* CHECK dout0_0 vdout0_0ck92 = 1.1 time = 465
* CHECK dout0_1 vdout0_1ck92 = 1.1 time = 465
* CHECK dout0_2 vdout0_2ck92 = 0 time = 465
* CHECK dout0_3 vdout0_3ck92 = 0 time = 465
* CHECK dout0_4 vdout0_4ck92 = 1.1 time = 465
* CHECK dout0_5 vdout0_5ck92 = 1.1 time = 465
* CHECK dout0_6 vdout0_6ck92 = 1.1 time = 465
* CHECK dout0_7 vdout0_7ck92 = 0 time = 465
* CHECK dout0_8 vdout0_8ck92 = 1.1 time = 465
* CHECK dout0_9 vdout0_9ck92 = 1.1 time = 465
* CHECK dout0_10 vdout0_10ck92 = 1.1 time = 465
* CHECK dout0_11 vdout0_11ck92 = 1.1 time = 465
* CHECK dout0_12 vdout0_12ck92 = 0 time = 465
* CHECK dout0_13 vdout0_13ck92 = 0 time = 465
* CHECK dout0_14 vdout0_14ck92 = 0 time = 465
* CHECK dout0_15 vdout0_15ck92 = 0 time = 465
* CHECK dout0_16 vdout0_16ck92 = 1.1 time = 465
* CHECK dout0_17 vdout0_17ck92 = 0 time = 465
* CHECK dout0_18 vdout0_18ck92 = 1.1 time = 465
* CHECK dout0_19 vdout0_19ck92 = 1.1 time = 465
* CHECK dout0_20 vdout0_20ck92 = 1.1 time = 465
* CHECK dout0_21 vdout0_21ck92 = 1.1 time = 465
* CHECK dout0_22 vdout0_22ck92 = 0 time = 465
* CHECK dout0_23 vdout0_23ck92 = 1.1 time = 465
* CHECK dout0_24 vdout0_24ck92 = 0 time = 465
* CHECK dout0_25 vdout0_25ck92 = 1.1 time = 465
* CHECK dout0_26 vdout0_26ck92 = 1.1 time = 465
* CHECK dout0_27 vdout0_27ck92 = 0 time = 465
* CHECK dout0_28 vdout0_28ck92 = 0 time = 465
* CHECK dout0_29 vdout0_29ck92 = 1.1 time = 465
* CHECK dout0_30 vdout0_30ck92 = 1.1 time = 465
* CHECK dout0_31 vdout0_31ck92 = 1.1 time = 465
* CHECK dout0_0 vdout0_0ck93 = 1.1 time = 470
* CHECK dout0_1 vdout0_1ck93 = 0 time = 470
* CHECK dout0_2 vdout0_2ck93 = 0 time = 470
* CHECK dout0_3 vdout0_3ck93 = 1.1 time = 470
* CHECK dout0_4 vdout0_4ck93 = 0 time = 470
* CHECK dout0_5 vdout0_5ck93 = 0 time = 470
* CHECK dout0_6 vdout0_6ck93 = 1.1 time = 470
* CHECK dout0_7 vdout0_7ck93 = 1.1 time = 470
* CHECK dout0_8 vdout0_8ck93 = 1.1 time = 470
* CHECK dout0_9 vdout0_9ck93 = 1.1 time = 470
* CHECK dout0_10 vdout0_10ck93 = 0 time = 470
* CHECK dout0_11 vdout0_11ck93 = 0 time = 470
* CHECK dout0_12 vdout0_12ck93 = 1.1 time = 470
* CHECK dout0_13 vdout0_13ck93 = 0 time = 470
* CHECK dout0_14 vdout0_14ck93 = 0 time = 470
* CHECK dout0_15 vdout0_15ck93 = 1.1 time = 470
* CHECK dout0_16 vdout0_16ck93 = 1.1 time = 470
* CHECK dout0_17 vdout0_17ck93 = 1.1 time = 470
* CHECK dout0_18 vdout0_18ck93 = 0 time = 470
* CHECK dout0_19 vdout0_19ck93 = 1.1 time = 470
* CHECK dout0_20 vdout0_20ck93 = 1.1 time = 470
* CHECK dout0_21 vdout0_21ck93 = 0 time = 470
* CHECK dout0_22 vdout0_22ck93 = 1.1 time = 470
* CHECK dout0_23 vdout0_23ck93 = 0 time = 470
* CHECK dout0_24 vdout0_24ck93 = 0 time = 470
* CHECK dout0_25 vdout0_25ck93 = 1.1 time = 470
* CHECK dout0_26 vdout0_26ck93 = 1.1 time = 470
* CHECK dout0_27 vdout0_27ck93 = 0 time = 470
* CHECK dout0_28 vdout0_28ck93 = 1.1 time = 470
* CHECK dout0_29 vdout0_29ck93 = 1.1 time = 470
* CHECK dout0_30 vdout0_30ck93 = 1.1 time = 470
* CHECK dout0_31 vdout0_31ck93 = 1.1 time = 470
* CHECK dout0_0 vdout0_0ck94 = 0 time = 475
* CHECK dout0_1 vdout0_1ck94 = 0 time = 475
* CHECK dout0_2 vdout0_2ck94 = 0 time = 475
* CHECK dout0_3 vdout0_3ck94 = 0 time = 475
* CHECK dout0_4 vdout0_4ck94 = 0 time = 475
* CHECK dout0_5 vdout0_5ck94 = 0 time = 475
* CHECK dout0_6 vdout0_6ck94 = 0 time = 475
* CHECK dout0_7 vdout0_7ck94 = 1.1 time = 475
* CHECK dout0_8 vdout0_8ck94 = 0 time = 475
* CHECK dout0_9 vdout0_9ck94 = 1.1 time = 475
* CHECK dout0_10 vdout0_10ck94 = 1.1 time = 475
* CHECK dout0_11 vdout0_11ck94 = 0 time = 475
* CHECK dout0_12 vdout0_12ck94 = 0 time = 475
* CHECK dout0_13 vdout0_13ck94 = 1.1 time = 475
* CHECK dout0_14 vdout0_14ck94 = 1.1 time = 475
* CHECK dout0_15 vdout0_15ck94 = 1.1 time = 475
* CHECK dout0_16 vdout0_16ck94 = 0 time = 475
* CHECK dout0_17 vdout0_17ck94 = 1.1 time = 475
* CHECK dout0_18 vdout0_18ck94 = 1.1 time = 475
* CHECK dout0_19 vdout0_19ck94 = 1.1 time = 475
* CHECK dout0_20 vdout0_20ck94 = 1.1 time = 475
* CHECK dout0_21 vdout0_21ck94 = 0 time = 475
* CHECK dout0_22 vdout0_22ck94 = 0 time = 475
* CHECK dout0_23 vdout0_23ck94 = 0 time = 475
* CHECK dout0_24 vdout0_24ck94 = 1.1 time = 475
* CHECK dout0_25 vdout0_25ck94 = 1.1 time = 475
* CHECK dout0_26 vdout0_26ck94 = 1.1 time = 475
* CHECK dout0_27 vdout0_27ck94 = 1.1 time = 475
* CHECK dout0_28 vdout0_28ck94 = 0 time = 475
* CHECK dout0_29 vdout0_29ck94 = 0 time = 475
* CHECK dout0_30 vdout0_30ck94 = 1.1 time = 475
* CHECK dout0_31 vdout0_31ck94 = 1.1 time = 475
* CHECK dout0_0 vdout0_0ck95 = 1.1 time = 480
* CHECK dout0_1 vdout0_1ck95 = 1.1 time = 480
* CHECK dout0_2 vdout0_2ck95 = 1.1 time = 480
* CHECK dout0_3 vdout0_3ck95 = 1.1 time = 480
* CHECK dout0_4 vdout0_4ck95 = 1.1 time = 480
* CHECK dout0_5 vdout0_5ck95 = 1.1 time = 480
* CHECK dout0_6 vdout0_6ck95 = 1.1 time = 480
* CHECK dout0_7 vdout0_7ck95 = 0 time = 480
* CHECK dout0_8 vdout0_8ck95 = 0 time = 480
* CHECK dout0_9 vdout0_9ck95 = 1.1 time = 480
* CHECK dout0_10 vdout0_10ck95 = 1.1 time = 480
* CHECK dout0_11 vdout0_11ck95 = 0 time = 480
* CHECK dout0_12 vdout0_12ck95 = 1.1 time = 480
* CHECK dout0_13 vdout0_13ck95 = 0 time = 480
* CHECK dout0_14 vdout0_14ck95 = 0 time = 480
* CHECK dout0_15 vdout0_15ck95 = 0 time = 480
* CHECK dout0_16 vdout0_16ck95 = 1.1 time = 480
* CHECK dout0_17 vdout0_17ck95 = 1.1 time = 480
* CHECK dout0_18 vdout0_18ck95 = 0 time = 480
* CHECK dout0_19 vdout0_19ck95 = 1.1 time = 480
* CHECK dout0_20 vdout0_20ck95 = 0 time = 480
* CHECK dout0_21 vdout0_21ck95 = 1.1 time = 480
* CHECK dout0_22 vdout0_22ck95 = 0 time = 480
* CHECK dout0_23 vdout0_23ck95 = 1.1 time = 480
* CHECK dout0_24 vdout0_24ck95 = 0 time = 480
* CHECK dout0_25 vdout0_25ck95 = 1.1 time = 480
* CHECK dout0_26 vdout0_26ck95 = 1.1 time = 480
* CHECK dout0_27 vdout0_27ck95 = 0 time = 480
* CHECK dout0_28 vdout0_28ck95 = 0 time = 480
* CHECK dout0_29 vdout0_29ck95 = 0 time = 480
* CHECK dout0_30 vdout0_30ck95 = 1.1 time = 480
* CHECK dout0_31 vdout0_31ck95 = 0 time = 480
* CHECK dout0_0 vdout0_0ck100 = 1.1 time = 505
* CHECK dout0_1 vdout0_1ck100 = 0 time = 505
* CHECK dout0_2 vdout0_2ck100 = 1.1 time = 505
* CHECK dout0_3 vdout0_3ck100 = 1.1 time = 505
* CHECK dout0_4 vdout0_4ck100 = 1.1 time = 505
* CHECK dout0_5 vdout0_5ck100 = 0 time = 505
* CHECK dout0_6 vdout0_6ck100 = 0 time = 505
* CHECK dout0_7 vdout0_7ck100 = 1.1 time = 505
* CHECK dout0_8 vdout0_8ck100 = 0 time = 505
* CHECK dout0_9 vdout0_9ck100 = 0 time = 505
* CHECK dout0_10 vdout0_10ck100 = 1.1 time = 505
* CHECK dout0_11 vdout0_11ck100 = 1.1 time = 505
* CHECK dout0_12 vdout0_12ck100 = 1.1 time = 505
* CHECK dout0_13 vdout0_13ck100 = 0 time = 505
* CHECK dout0_14 vdout0_14ck100 = 0 time = 505
* CHECK dout0_15 vdout0_15ck100 = 1.1 time = 505
* CHECK dout0_16 vdout0_16ck100 = 0 time = 505
* CHECK dout0_17 vdout0_17ck100 = 1.1 time = 505
* CHECK dout0_18 vdout0_18ck100 = 1.1 time = 505
* CHECK dout0_19 vdout0_19ck100 = 1.1 time = 505
* CHECK dout0_20 vdout0_20ck100 = 0 time = 505
* CHECK dout0_21 vdout0_21ck100 = 0 time = 505
* CHECK dout0_22 vdout0_22ck100 = 0 time = 505
* CHECK dout0_23 vdout0_23ck100 = 1.1 time = 505
* CHECK dout0_24 vdout0_24ck100 = 1.1 time = 505
* CHECK dout0_25 vdout0_25ck100 = 0 time = 505
* CHECK dout0_26 vdout0_26ck100 = 0 time = 505
* CHECK dout0_27 vdout0_27ck100 = 0 time = 505
* CHECK dout0_28 vdout0_28ck100 = 0 time = 505
* CHECK dout0_29 vdout0_29ck100 = 1.1 time = 505
* CHECK dout0_30 vdout0_30ck100 = 1.1 time = 505
* CHECK dout0_31 vdout0_31ck100 = 0 time = 505
* CHECK dout0_0 vdout0_0ck101 = 1.1 time = 510
* CHECK dout0_1 vdout0_1ck101 = 0 time = 510
* CHECK dout0_2 vdout0_2ck101 = 0 time = 510
* CHECK dout0_3 vdout0_3ck101 = 1.1 time = 510
* CHECK dout0_4 vdout0_4ck101 = 0 time = 510
* CHECK dout0_5 vdout0_5ck101 = 0 time = 510
* CHECK dout0_6 vdout0_6ck101 = 1.1 time = 510
* CHECK dout0_7 vdout0_7ck101 = 1.1 time = 510
* CHECK dout0_8 vdout0_8ck101 = 1.1 time = 510
* CHECK dout0_9 vdout0_9ck101 = 1.1 time = 510
* CHECK dout0_10 vdout0_10ck101 = 0 time = 510
* CHECK dout0_11 vdout0_11ck101 = 0 time = 510
* CHECK dout0_12 vdout0_12ck101 = 1.1 time = 510
* CHECK dout0_13 vdout0_13ck101 = 0 time = 510
* CHECK dout0_14 vdout0_14ck101 = 0 time = 510
* CHECK dout0_15 vdout0_15ck101 = 1.1 time = 510
* CHECK dout0_16 vdout0_16ck101 = 1.1 time = 510
* CHECK dout0_17 vdout0_17ck101 = 1.1 time = 510
* CHECK dout0_18 vdout0_18ck101 = 0 time = 510
* CHECK dout0_19 vdout0_19ck101 = 1.1 time = 510
* CHECK dout0_20 vdout0_20ck101 = 1.1 time = 510
* CHECK dout0_21 vdout0_21ck101 = 0 time = 510
* CHECK dout0_22 vdout0_22ck101 = 1.1 time = 510
* CHECK dout0_23 vdout0_23ck101 = 0 time = 510
* CHECK dout0_24 vdout0_24ck101 = 0 time = 510
* CHECK dout0_25 vdout0_25ck101 = 1.1 time = 510
* CHECK dout0_26 vdout0_26ck101 = 1.1 time = 510
* CHECK dout0_27 vdout0_27ck101 = 0 time = 510
* CHECK dout0_28 vdout0_28ck101 = 1.1 time = 510
* CHECK dout0_29 vdout0_29ck101 = 1.1 time = 510
* CHECK dout0_30 vdout0_30ck101 = 1.1 time = 510
* CHECK dout0_31 vdout0_31ck101 = 1.1 time = 510
* CHECK dout0_0 vdout0_0ck102 = 1.1 time = 515
* CHECK dout0_1 vdout0_1ck102 = 1.1 time = 515
* CHECK dout0_2 vdout0_2ck102 = 0 time = 515
* CHECK dout0_3 vdout0_3ck102 = 0 time = 515
* CHECK dout0_4 vdout0_4ck102 = 1.1 time = 515
* CHECK dout0_5 vdout0_5ck102 = 1.1 time = 515
* CHECK dout0_6 vdout0_6ck102 = 1.1 time = 515
* CHECK dout0_7 vdout0_7ck102 = 0 time = 515
* CHECK dout0_8 vdout0_8ck102 = 1.1 time = 515
* CHECK dout0_9 vdout0_9ck102 = 1.1 time = 515
* CHECK dout0_10 vdout0_10ck102 = 1.1 time = 515
* CHECK dout0_11 vdout0_11ck102 = 1.1 time = 515
* CHECK dout0_12 vdout0_12ck102 = 0 time = 515
* CHECK dout0_13 vdout0_13ck102 = 0 time = 515
* CHECK dout0_14 vdout0_14ck102 = 0 time = 515
* CHECK dout0_15 vdout0_15ck102 = 0 time = 515
* CHECK dout0_16 vdout0_16ck102 = 1.1 time = 515
* CHECK dout0_17 vdout0_17ck102 = 0 time = 515
* CHECK dout0_18 vdout0_18ck102 = 1.1 time = 515
* CHECK dout0_19 vdout0_19ck102 = 1.1 time = 515
* CHECK dout0_20 vdout0_20ck102 = 1.1 time = 515
* CHECK dout0_21 vdout0_21ck102 = 1.1 time = 515
* CHECK dout0_22 vdout0_22ck102 = 0 time = 515
* CHECK dout0_23 vdout0_23ck102 = 1.1 time = 515
* CHECK dout0_24 vdout0_24ck102 = 0 time = 515
* CHECK dout0_25 vdout0_25ck102 = 1.1 time = 515
* CHECK dout0_26 vdout0_26ck102 = 1.1 time = 515
* CHECK dout0_27 vdout0_27ck102 = 0 time = 515
* CHECK dout0_28 vdout0_28ck102 = 0 time = 515
* CHECK dout0_29 vdout0_29ck102 = 1.1 time = 515
* CHECK dout0_30 vdout0_30ck102 = 1.1 time = 515
* CHECK dout0_31 vdout0_31ck102 = 1.1 time = 515
* CHECK dout0_0 vdout0_0ck112 = 1.1 time = 565
* CHECK dout0_1 vdout0_1ck112 = 0 time = 565
* CHECK dout0_2 vdout0_2ck112 = 1.1 time = 565
* CHECK dout0_3 vdout0_3ck112 = 1.1 time = 565
* CHECK dout0_4 vdout0_4ck112 = 1.1 time = 565
* CHECK dout0_5 vdout0_5ck112 = 0 time = 565
* CHECK dout0_6 vdout0_6ck112 = 0 time = 565
* CHECK dout0_7 vdout0_7ck112 = 1.1 time = 565
* CHECK dout0_8 vdout0_8ck112 = 0 time = 565
* CHECK dout0_9 vdout0_9ck112 = 0 time = 565
* CHECK dout0_10 vdout0_10ck112 = 1.1 time = 565
* CHECK dout0_11 vdout0_11ck112 = 1.1 time = 565
* CHECK dout0_12 vdout0_12ck112 = 1.1 time = 565
* CHECK dout0_13 vdout0_13ck112 = 0 time = 565
* CHECK dout0_14 vdout0_14ck112 = 0 time = 565
* CHECK dout0_15 vdout0_15ck112 = 1.1 time = 565
* CHECK dout0_16 vdout0_16ck112 = 0 time = 565
* CHECK dout0_17 vdout0_17ck112 = 1.1 time = 565
* CHECK dout0_18 vdout0_18ck112 = 1.1 time = 565
* CHECK dout0_19 vdout0_19ck112 = 1.1 time = 565
* CHECK dout0_20 vdout0_20ck112 = 0 time = 565
* CHECK dout0_21 vdout0_21ck112 = 0 time = 565
* CHECK dout0_22 vdout0_22ck112 = 0 time = 565
* CHECK dout0_23 vdout0_23ck112 = 1.1 time = 565
* CHECK dout0_24 vdout0_24ck112 = 1.1 time = 565
* CHECK dout0_25 vdout0_25ck112 = 0 time = 565
* CHECK dout0_26 vdout0_26ck112 = 0 time = 565
* CHECK dout0_27 vdout0_27ck112 = 0 time = 565
* CHECK dout0_28 vdout0_28ck112 = 0 time = 565
* CHECK dout0_29 vdout0_29ck112 = 1.1 time = 565
* CHECK dout0_30 vdout0_30ck112 = 1.1 time = 565
* CHECK dout0_31 vdout0_31ck112 = 0 time = 565
* CHECK dout0_0 vdout0_0ck113 = 0 time = 570
* CHECK dout0_1 vdout0_1ck113 = 1.1 time = 570
* CHECK dout0_2 vdout0_2ck113 = 1.1 time = 570
* CHECK dout0_3 vdout0_3ck113 = 1.1 time = 570
* CHECK dout0_4 vdout0_4ck113 = 1.1 time = 570
* CHECK dout0_5 vdout0_5ck113 = 0 time = 570
* CHECK dout0_6 vdout0_6ck113 = 1.1 time = 570
* CHECK dout0_7 vdout0_7ck113 = 0 time = 570
* CHECK dout0_8 vdout0_8ck113 = 0 time = 570
* CHECK dout0_9 vdout0_9ck113 = 0 time = 570
* CHECK dout0_10 vdout0_10ck113 = 1.1 time = 570
* CHECK dout0_11 vdout0_11ck113 = 0 time = 570
* CHECK dout0_12 vdout0_12ck113 = 0 time = 570
* CHECK dout0_13 vdout0_13ck113 = 0 time = 570
* CHECK dout0_14 vdout0_14ck113 = 0 time = 570
* CHECK dout0_15 vdout0_15ck113 = 0 time = 570
* CHECK dout0_16 vdout0_16ck113 = 0 time = 570
* CHECK dout0_17 vdout0_17ck113 = 1.1 time = 570
* CHECK dout0_18 vdout0_18ck113 = 0 time = 570
* CHECK dout0_19 vdout0_19ck113 = 0 time = 570
* CHECK dout0_20 vdout0_20ck113 = 0 time = 570
* CHECK dout0_21 vdout0_21ck113 = 1.1 time = 570
* CHECK dout0_22 vdout0_22ck113 = 1.1 time = 570
* CHECK dout0_23 vdout0_23ck113 = 1.1 time = 570
* CHECK dout0_24 vdout0_24ck113 = 0 time = 570
* CHECK dout0_25 vdout0_25ck113 = 1.1 time = 570
* CHECK dout0_26 vdout0_26ck113 = 1.1 time = 570
* CHECK dout0_27 vdout0_27ck113 = 0 time = 570
* CHECK dout0_28 vdout0_28ck113 = 0 time = 570
* CHECK dout0_29 vdout0_29ck113 = 1.1 time = 570
* CHECK dout0_30 vdout0_30ck113 = 1.1 time = 570
* CHECK dout0_31 vdout0_31ck113 = 1.1 time = 570
* CHECK dout0_0 vdout0_0ck116 = 0 time = 585
* CHECK dout0_1 vdout0_1ck116 = 0 time = 585
* CHECK dout0_2 vdout0_2ck116 = 0 time = 585
* CHECK dout0_3 vdout0_3ck116 = 1.1 time = 585
* CHECK dout0_4 vdout0_4ck116 = 0 time = 585
* CHECK dout0_5 vdout0_5ck116 = 0 time = 585
* CHECK dout0_6 vdout0_6ck116 = 1.1 time = 585
* CHECK dout0_7 vdout0_7ck116 = 0 time = 585
* CHECK dout0_8 vdout0_8ck116 = 0 time = 585
* CHECK dout0_9 vdout0_9ck116 = 0 time = 585
* CHECK dout0_10 vdout0_10ck116 = 1.1 time = 585
* CHECK dout0_11 vdout0_11ck116 = 1.1 time = 585
* CHECK dout0_12 vdout0_12ck116 = 1.1 time = 585
* CHECK dout0_13 vdout0_13ck116 = 0 time = 585
* CHECK dout0_14 vdout0_14ck116 = 0 time = 585
* CHECK dout0_15 vdout0_15ck116 = 1.1 time = 585
* CHECK dout0_16 vdout0_16ck116 = 1.1 time = 585
* CHECK dout0_17 vdout0_17ck116 = 0 time = 585
* CHECK dout0_18 vdout0_18ck116 = 0 time = 585
* CHECK dout0_19 vdout0_19ck116 = 0 time = 585
* CHECK dout0_20 vdout0_20ck116 = 1.1 time = 585
* CHECK dout0_21 vdout0_21ck116 = 0 time = 585
* CHECK dout0_22 vdout0_22ck116 = 0 time = 585
* CHECK dout0_23 vdout0_23ck116 = 0 time = 585
* CHECK dout0_24 vdout0_24ck116 = 1.1 time = 585
* CHECK dout0_25 vdout0_25ck116 = 0 time = 585
* CHECK dout0_26 vdout0_26ck116 = 0 time = 585
* CHECK dout0_27 vdout0_27ck116 = 0 time = 585
* CHECK dout0_28 vdout0_28ck116 = 0 time = 585
* CHECK dout0_29 vdout0_29ck116 = 0 time = 585
* CHECK dout0_30 vdout0_30ck116 = 0 time = 585
* CHECK dout0_31 vdout0_31ck116 = 0 time = 585
* CHECK dout0_0 vdout0_0ck119 = 1.1 time = 600
* CHECK dout0_1 vdout0_1ck119 = 0 time = 600
* CHECK dout0_2 vdout0_2ck119 = 0 time = 600
* CHECK dout0_3 vdout0_3ck119 = 1.1 time = 600
* CHECK dout0_4 vdout0_4ck119 = 0 time = 600
* CHECK dout0_5 vdout0_5ck119 = 0 time = 600
* CHECK dout0_6 vdout0_6ck119 = 0 time = 600
* CHECK dout0_7 vdout0_7ck119 = 0 time = 600
* CHECK dout0_8 vdout0_8ck119 = 0 time = 600
* CHECK dout0_9 vdout0_9ck119 = 0 time = 600
* CHECK dout0_10 vdout0_10ck119 = 1.1 time = 600
* CHECK dout0_11 vdout0_11ck119 = 0 time = 600
* CHECK dout0_12 vdout0_12ck119 = 1.1 time = 600
* CHECK dout0_13 vdout0_13ck119 = 1.1 time = 600
* CHECK dout0_14 vdout0_14ck119 = 1.1 time = 600
* CHECK dout0_15 vdout0_15ck119 = 1.1 time = 600
* CHECK dout0_16 vdout0_16ck119 = 0 time = 600
* CHECK dout0_17 vdout0_17ck119 = 0 time = 600
* CHECK dout0_18 vdout0_18ck119 = 1.1 time = 600
* CHECK dout0_19 vdout0_19ck119 = 0 time = 600
* CHECK dout0_20 vdout0_20ck119 = 0 time = 600
* CHECK dout0_21 vdout0_21ck119 = 1.1 time = 600
* CHECK dout0_22 vdout0_22ck119 = 1.1 time = 600
* CHECK dout0_23 vdout0_23ck119 = 1.1 time = 600
* CHECK dout0_24 vdout0_24ck119 = 0 time = 600
* CHECK dout0_25 vdout0_25ck119 = 1.1 time = 600
* CHECK dout0_26 vdout0_26ck119 = 1.1 time = 600
* CHECK dout0_27 vdout0_27ck119 = 0 time = 600
* CHECK dout0_28 vdout0_28ck119 = 0 time = 600
* CHECK dout0_29 vdout0_29ck119 = 1.1 time = 600
* CHECK dout0_30 vdout0_30ck119 = 1.1 time = 600
* CHECK dout0_31 vdout0_31ck119 = 0 time = 600
* CHECK dout0_0 vdout0_0ck121 = 1.1 time = 610
* CHECK dout0_1 vdout0_1ck121 = 0 time = 610
* CHECK dout0_2 vdout0_2ck121 = 1.1 time = 610
* CHECK dout0_3 vdout0_3ck121 = 0 time = 610
* CHECK dout0_4 vdout0_4ck121 = 0 time = 610
* CHECK dout0_5 vdout0_5ck121 = 0 time = 610
* CHECK dout0_6 vdout0_6ck121 = 0 time = 610
* CHECK dout0_7 vdout0_7ck121 = 1.1 time = 610
* CHECK dout0_8 vdout0_8ck121 = 1.1 time = 610
* CHECK dout0_9 vdout0_9ck121 = 1.1 time = 610
* CHECK dout0_10 vdout0_10ck121 = 1.1 time = 610
* CHECK dout0_11 vdout0_11ck121 = 0 time = 610
* CHECK dout0_12 vdout0_12ck121 = 1.1 time = 610
* CHECK dout0_13 vdout0_13ck121 = 1.1 time = 610
* CHECK dout0_14 vdout0_14ck121 = 1.1 time = 610
* CHECK dout0_15 vdout0_15ck121 = 1.1 time = 610
* CHECK dout0_16 vdout0_16ck121 = 0 time = 610
* CHECK dout0_17 vdout0_17ck121 = 1.1 time = 610
* CHECK dout0_18 vdout0_18ck121 = 0 time = 610
* CHECK dout0_19 vdout0_19ck121 = 1.1 time = 610
* CHECK dout0_20 vdout0_20ck121 = 0 time = 610
* CHECK dout0_21 vdout0_21ck121 = 1.1 time = 610
* CHECK dout0_22 vdout0_22ck121 = 1.1 time = 610
* CHECK dout0_23 vdout0_23ck121 = 1.1 time = 610
* CHECK dout0_24 vdout0_24ck121 = 0 time = 610
* CHECK dout0_25 vdout0_25ck121 = 0 time = 610
* CHECK dout0_26 vdout0_26ck121 = 1.1 time = 610
* CHECK dout0_27 vdout0_27ck121 = 0 time = 610
* CHECK dout0_28 vdout0_28ck121 = 0 time = 610
* CHECK dout0_29 vdout0_29ck121 = 0 time = 610
* CHECK dout0_30 vdout0_30ck121 = 0 time = 610
* CHECK dout0_31 vdout0_31ck121 = 1.1 time = 610
* CHECK dout0_0 vdout0_0ck122 = 1.1 time = 615
* CHECK dout0_1 vdout0_1ck122 = 0 time = 615
* CHECK dout0_2 vdout0_2ck122 = 1.1 time = 615
* CHECK dout0_3 vdout0_3ck122 = 0 time = 615
* CHECK dout0_4 vdout0_4ck122 = 0 time = 615
* CHECK dout0_5 vdout0_5ck122 = 0 time = 615
* CHECK dout0_6 vdout0_6ck122 = 0 time = 615
* CHECK dout0_7 vdout0_7ck122 = 1.1 time = 615
* CHECK dout0_8 vdout0_8ck122 = 1.1 time = 615
* CHECK dout0_9 vdout0_9ck122 = 1.1 time = 615
* CHECK dout0_10 vdout0_10ck122 = 1.1 time = 615
* CHECK dout0_11 vdout0_11ck122 = 0 time = 615
* CHECK dout0_12 vdout0_12ck122 = 1.1 time = 615
* CHECK dout0_13 vdout0_13ck122 = 1.1 time = 615
* CHECK dout0_14 vdout0_14ck122 = 1.1 time = 615
* CHECK dout0_15 vdout0_15ck122 = 1.1 time = 615
* CHECK dout0_16 vdout0_16ck122 = 0 time = 615
* CHECK dout0_17 vdout0_17ck122 = 1.1 time = 615
* CHECK dout0_18 vdout0_18ck122 = 0 time = 615
* CHECK dout0_19 vdout0_19ck122 = 1.1 time = 615
* CHECK dout0_20 vdout0_20ck122 = 0 time = 615
* CHECK dout0_21 vdout0_21ck122 = 1.1 time = 615
* CHECK dout0_22 vdout0_22ck122 = 1.1 time = 615
* CHECK dout0_23 vdout0_23ck122 = 1.1 time = 615
* CHECK dout0_24 vdout0_24ck122 = 0 time = 615
* CHECK dout0_25 vdout0_25ck122 = 0 time = 615
* CHECK dout0_26 vdout0_26ck122 = 1.1 time = 615
* CHECK dout0_27 vdout0_27ck122 = 0 time = 615
* CHECK dout0_28 vdout0_28ck122 = 0 time = 615
* CHECK dout0_29 vdout0_29ck122 = 0 time = 615
* CHECK dout0_30 vdout0_30ck122 = 0 time = 615
* CHECK dout0_31 vdout0_31ck122 = 1.1 time = 615
* CHECK dout0_0 vdout0_0ck125 = 0 time = 630
* CHECK dout0_1 vdout0_1ck125 = 0 time = 630
* CHECK dout0_2 vdout0_2ck125 = 1.1 time = 630
* CHECK dout0_3 vdout0_3ck125 = 0 time = 630
* CHECK dout0_4 vdout0_4ck125 = 0 time = 630
* CHECK dout0_5 vdout0_5ck125 = 1.1 time = 630
* CHECK dout0_6 vdout0_6ck125 = 0 time = 630
* CHECK dout0_7 vdout0_7ck125 = 1.1 time = 630
* CHECK dout0_8 vdout0_8ck125 = 1.1 time = 630
* CHECK dout0_9 vdout0_9ck125 = 1.1 time = 630
* CHECK dout0_10 vdout0_10ck125 = 1.1 time = 630
* CHECK dout0_11 vdout0_11ck125 = 1.1 time = 630
* CHECK dout0_12 vdout0_12ck125 = 0 time = 630
* CHECK dout0_13 vdout0_13ck125 = 0 time = 630
* CHECK dout0_14 vdout0_14ck125 = 0 time = 630
* CHECK dout0_15 vdout0_15ck125 = 0 time = 630
* CHECK dout0_16 vdout0_16ck125 = 1.1 time = 630
* CHECK dout0_17 vdout0_17ck125 = 0 time = 630
* CHECK dout0_18 vdout0_18ck125 = 0 time = 630
* CHECK dout0_19 vdout0_19ck125 = 0 time = 630
* CHECK dout0_20 vdout0_20ck125 = 1.1 time = 630
* CHECK dout0_21 vdout0_21ck125 = 1.1 time = 630
* CHECK dout0_22 vdout0_22ck125 = 0 time = 630
* CHECK dout0_23 vdout0_23ck125 = 0 time = 630
* CHECK dout0_24 vdout0_24ck125 = 1.1 time = 630
* CHECK dout0_25 vdout0_25ck125 = 1.1 time = 630
* CHECK dout0_26 vdout0_26ck125 = 1.1 time = 630
* CHECK dout0_27 vdout0_27ck125 = 1.1 time = 630
* CHECK dout0_28 vdout0_28ck125 = 1.1 time = 630
* CHECK dout0_29 vdout0_29ck125 = 0 time = 630
* CHECK dout0_30 vdout0_30ck125 = 0 time = 630
* CHECK dout0_31 vdout0_31ck125 = 0 time = 630
* CHECK dout0_0 vdout0_0ck126 = 1.1 time = 635
* CHECK dout0_1 vdout0_1ck126 = 0 time = 635
* CHECK dout0_2 vdout0_2ck126 = 1.1 time = 635
* CHECK dout0_3 vdout0_3ck126 = 1.1 time = 635
* CHECK dout0_4 vdout0_4ck126 = 1.1 time = 635
* CHECK dout0_5 vdout0_5ck126 = 0 time = 635
* CHECK dout0_6 vdout0_6ck126 = 0 time = 635
* CHECK dout0_7 vdout0_7ck126 = 1.1 time = 635
* CHECK dout0_8 vdout0_8ck126 = 0 time = 635
* CHECK dout0_9 vdout0_9ck126 = 0 time = 635
* CHECK dout0_10 vdout0_10ck126 = 1.1 time = 635
* CHECK dout0_11 vdout0_11ck126 = 1.1 time = 635
* CHECK dout0_12 vdout0_12ck126 = 1.1 time = 635
* CHECK dout0_13 vdout0_13ck126 = 0 time = 635
* CHECK dout0_14 vdout0_14ck126 = 0 time = 635
* CHECK dout0_15 vdout0_15ck126 = 1.1 time = 635
* CHECK dout0_16 vdout0_16ck126 = 0 time = 635
* CHECK dout0_17 vdout0_17ck126 = 1.1 time = 635
* CHECK dout0_18 vdout0_18ck126 = 1.1 time = 635
* CHECK dout0_19 vdout0_19ck126 = 1.1 time = 635
* CHECK dout0_20 vdout0_20ck126 = 0 time = 635
* CHECK dout0_21 vdout0_21ck126 = 0 time = 635
* CHECK dout0_22 vdout0_22ck126 = 0 time = 635
* CHECK dout0_23 vdout0_23ck126 = 1.1 time = 635
* CHECK dout0_24 vdout0_24ck126 = 1.1 time = 635
* CHECK dout0_25 vdout0_25ck126 = 0 time = 635
* CHECK dout0_26 vdout0_26ck126 = 0 time = 635
* CHECK dout0_27 vdout0_27ck126 = 0 time = 635
* CHECK dout0_28 vdout0_28ck126 = 0 time = 635
* CHECK dout0_29 vdout0_29ck126 = 1.1 time = 635
* CHECK dout0_30 vdout0_30ck126 = 1.1 time = 635
* CHECK dout0_31 vdout0_31ck126 = 0 time = 635
* CHECK dout0_0 vdout0_0ck127 = 0 time = 640
* CHECK dout0_1 vdout0_1ck127 = 0 time = 640
* CHECK dout0_2 vdout0_2ck127 = 1.1 time = 640
* CHECK dout0_3 vdout0_3ck127 = 0 time = 640
* CHECK dout0_4 vdout0_4ck127 = 0 time = 640
* CHECK dout0_5 vdout0_5ck127 = 1.1 time = 640
* CHECK dout0_6 vdout0_6ck127 = 0 time = 640
* CHECK dout0_7 vdout0_7ck127 = 1.1 time = 640
* CHECK dout0_8 vdout0_8ck127 = 1.1 time = 640
* CHECK dout0_9 vdout0_9ck127 = 1.1 time = 640
* CHECK dout0_10 vdout0_10ck127 = 1.1 time = 640
* CHECK dout0_11 vdout0_11ck127 = 1.1 time = 640
* CHECK dout0_12 vdout0_12ck127 = 0 time = 640
* CHECK dout0_13 vdout0_13ck127 = 0 time = 640
* CHECK dout0_14 vdout0_14ck127 = 0 time = 640
* CHECK dout0_15 vdout0_15ck127 = 0 time = 640
* CHECK dout0_16 vdout0_16ck127 = 1.1 time = 640
* CHECK dout0_17 vdout0_17ck127 = 0 time = 640
* CHECK dout0_18 vdout0_18ck127 = 0 time = 640
* CHECK dout0_19 vdout0_19ck127 = 0 time = 640
* CHECK dout0_20 vdout0_20ck127 = 1.1 time = 640
* CHECK dout0_21 vdout0_21ck127 = 1.1 time = 640
* CHECK dout0_22 vdout0_22ck127 = 0 time = 640
* CHECK dout0_23 vdout0_23ck127 = 0 time = 640
* CHECK dout0_24 vdout0_24ck127 = 1.1 time = 640
* CHECK dout0_25 vdout0_25ck127 = 1.1 time = 640
* CHECK dout0_26 vdout0_26ck127 = 1.1 time = 640
* CHECK dout0_27 vdout0_27ck127 = 1.1 time = 640
* CHECK dout0_28 vdout0_28ck127 = 1.1 time = 640
* CHECK dout0_29 vdout0_29ck127 = 0 time = 640
* CHECK dout0_30 vdout0_30ck127 = 0 time = 640
* CHECK dout0_31 vdout0_31ck127 = 0 time = 640
* CHECK dout0_0 vdout0_0ck128 = 1.1 time = 645
* CHECK dout0_1 vdout0_1ck128 = 0 time = 645
* CHECK dout0_2 vdout0_2ck128 = 0 time = 645
* CHECK dout0_3 vdout0_3ck128 = 1.1 time = 645
* CHECK dout0_4 vdout0_4ck128 = 0 time = 645
* CHECK dout0_5 vdout0_5ck128 = 0 time = 645
* CHECK dout0_6 vdout0_6ck128 = 1.1 time = 645
* CHECK dout0_7 vdout0_7ck128 = 1.1 time = 645
* CHECK dout0_8 vdout0_8ck128 = 1.1 time = 645
* CHECK dout0_9 vdout0_9ck128 = 1.1 time = 645
* CHECK dout0_10 vdout0_10ck128 = 1.1 time = 645
* CHECK dout0_11 vdout0_11ck128 = 0 time = 645
* CHECK dout0_12 vdout0_12ck128 = 1.1 time = 645
* CHECK dout0_13 vdout0_13ck128 = 0 time = 645
* CHECK dout0_14 vdout0_14ck128 = 0 time = 645
* CHECK dout0_15 vdout0_15ck128 = 0 time = 645
* CHECK dout0_16 vdout0_16ck128 = 0 time = 645
* CHECK dout0_17 vdout0_17ck128 = 0 time = 645
* CHECK dout0_18 vdout0_18ck128 = 0 time = 645
* CHECK dout0_19 vdout0_19ck128 = 1.1 time = 645
* CHECK dout0_20 vdout0_20ck128 = 1.1 time = 645
* CHECK dout0_21 vdout0_21ck128 = 1.1 time = 645
* CHECK dout0_22 vdout0_22ck128 = 1.1 time = 645
* CHECK dout0_23 vdout0_23ck128 = 0 time = 645
* CHECK dout0_24 vdout0_24ck128 = 0 time = 645
* CHECK dout0_25 vdout0_25ck128 = 1.1 time = 645
* CHECK dout0_26 vdout0_26ck128 = 1.1 time = 645
* CHECK dout0_27 vdout0_27ck128 = 1.1 time = 645
* CHECK dout0_28 vdout0_28ck128 = 0 time = 645
* CHECK dout0_29 vdout0_29ck128 = 0 time = 645
* CHECK dout0_30 vdout0_30ck128 = 0 time = 645
* CHECK dout0_31 vdout0_31ck128 = 0 time = 645
* CHECK dout0_0 vdout0_0ck129 = 0 time = 650
* CHECK dout0_1 vdout0_1ck129 = 0 time = 650
* CHECK dout0_2 vdout0_2ck129 = 1.1 time = 650
* CHECK dout0_3 vdout0_3ck129 = 0 time = 650
* CHECK dout0_4 vdout0_4ck129 = 0 time = 650
* CHECK dout0_5 vdout0_5ck129 = 1.1 time = 650
* CHECK dout0_6 vdout0_6ck129 = 0 time = 650
* CHECK dout0_7 vdout0_7ck129 = 1.1 time = 650
* CHECK dout0_8 vdout0_8ck129 = 1.1 time = 650
* CHECK dout0_9 vdout0_9ck129 = 1.1 time = 650
* CHECK dout0_10 vdout0_10ck129 = 1.1 time = 650
* CHECK dout0_11 vdout0_11ck129 = 1.1 time = 650
* CHECK dout0_12 vdout0_12ck129 = 0 time = 650
* CHECK dout0_13 vdout0_13ck129 = 0 time = 650
* CHECK dout0_14 vdout0_14ck129 = 0 time = 650
* CHECK dout0_15 vdout0_15ck129 = 0 time = 650
* CHECK dout0_16 vdout0_16ck129 = 1.1 time = 650
* CHECK dout0_17 vdout0_17ck129 = 0 time = 650
* CHECK dout0_18 vdout0_18ck129 = 0 time = 650
* CHECK dout0_19 vdout0_19ck129 = 0 time = 650
* CHECK dout0_20 vdout0_20ck129 = 1.1 time = 650
* CHECK dout0_21 vdout0_21ck129 = 1.1 time = 650
* CHECK dout0_22 vdout0_22ck129 = 0 time = 650
* CHECK dout0_23 vdout0_23ck129 = 0 time = 650
* CHECK dout0_24 vdout0_24ck129 = 1.1 time = 650
* CHECK dout0_25 vdout0_25ck129 = 1.1 time = 650
* CHECK dout0_26 vdout0_26ck129 = 1.1 time = 650
* CHECK dout0_27 vdout0_27ck129 = 1.1 time = 650
* CHECK dout0_28 vdout0_28ck129 = 1.1 time = 650
* CHECK dout0_29 vdout0_29ck129 = 0 time = 650
* CHECK dout0_30 vdout0_30ck129 = 0 time = 650
* CHECK dout0_31 vdout0_31ck129 = 0 time = 650
* CHECK dout0_0 vdout0_0ck133 = 1.1 time = 670
* CHECK dout0_1 vdout0_1ck133 = 0 time = 670
* CHECK dout0_2 vdout0_2ck133 = 1.1 time = 670
* CHECK dout0_3 vdout0_3ck133 = 1.1 time = 670
* CHECK dout0_4 vdout0_4ck133 = 0 time = 670
* CHECK dout0_5 vdout0_5ck133 = 0 time = 670
* CHECK dout0_6 vdout0_6ck133 = 1.1 time = 670
* CHECK dout0_7 vdout0_7ck133 = 1.1 time = 670
* CHECK dout0_8 vdout0_8ck133 = 1.1 time = 670
* CHECK dout0_9 vdout0_9ck133 = 0 time = 670
* CHECK dout0_10 vdout0_10ck133 = 1.1 time = 670
* CHECK dout0_11 vdout0_11ck133 = 1.1 time = 670
* CHECK dout0_12 vdout0_12ck133 = 0 time = 670
* CHECK dout0_13 vdout0_13ck133 = 0 time = 670
* CHECK dout0_14 vdout0_14ck133 = 0 time = 670
* CHECK dout0_15 vdout0_15ck133 = 1.1 time = 670
* CHECK dout0_16 vdout0_16ck133 = 0 time = 670
* CHECK dout0_17 vdout0_17ck133 = 0 time = 670
* CHECK dout0_18 vdout0_18ck133 = 0 time = 670
* CHECK dout0_19 vdout0_19ck133 = 0 time = 670
* CHECK dout0_20 vdout0_20ck133 = 1.1 time = 670
* CHECK dout0_21 vdout0_21ck133 = 1.1 time = 670
* CHECK dout0_22 vdout0_22ck133 = 0 time = 670
* CHECK dout0_23 vdout0_23ck133 = 0 time = 670
* CHECK dout0_24 vdout0_24ck133 = 0 time = 670
* CHECK dout0_25 vdout0_25ck133 = 0 time = 670
* CHECK dout0_26 vdout0_26ck133 = 0 time = 670
* CHECK dout0_27 vdout0_27ck133 = 1.1 time = 670
* CHECK dout0_28 vdout0_28ck133 = 0 time = 670
* CHECK dout0_29 vdout0_29ck133 = 1.1 time = 670
* CHECK dout0_30 vdout0_30ck133 = 1.1 time = 670
* CHECK dout0_31 vdout0_31ck133 = 0 time = 670
* CHECK dout0_0 vdout0_0ck134 = 1.1 time = 675
* CHECK dout0_1 vdout0_1ck134 = 1.1 time = 675
* CHECK dout0_2 vdout0_2ck134 = 1.1 time = 675
* CHECK dout0_3 vdout0_3ck134 = 1.1 time = 675
* CHECK dout0_4 vdout0_4ck134 = 1.1 time = 675
* CHECK dout0_5 vdout0_5ck134 = 0 time = 675
* CHECK dout0_6 vdout0_6ck134 = 0 time = 675
* CHECK dout0_7 vdout0_7ck134 = 0 time = 675
* CHECK dout0_8 vdout0_8ck134 = 1.1 time = 675
* CHECK dout0_9 vdout0_9ck134 = 0 time = 675
* CHECK dout0_10 vdout0_10ck134 = 0 time = 675
* CHECK dout0_11 vdout0_11ck134 = 0 time = 675
* CHECK dout0_12 vdout0_12ck134 = 0 time = 675
* CHECK dout0_13 vdout0_13ck134 = 1.1 time = 675
* CHECK dout0_14 vdout0_14ck134 = 1.1 time = 675
* CHECK dout0_15 vdout0_15ck134 = 0 time = 675
* CHECK dout0_16 vdout0_16ck134 = 0 time = 675
* CHECK dout0_17 vdout0_17ck134 = 0 time = 675
* CHECK dout0_18 vdout0_18ck134 = 0 time = 675
* CHECK dout0_19 vdout0_19ck134 = 0 time = 675
* CHECK dout0_20 vdout0_20ck134 = 0 time = 675
* CHECK dout0_21 vdout0_21ck134 = 0 time = 675
* CHECK dout0_22 vdout0_22ck134 = 0 time = 675
* CHECK dout0_23 vdout0_23ck134 = 1.1 time = 675
* CHECK dout0_24 vdout0_24ck134 = 0 time = 675
* CHECK dout0_25 vdout0_25ck134 = 0 time = 675
* CHECK dout0_26 vdout0_26ck134 = 1.1 time = 675
* CHECK dout0_27 vdout0_27ck134 = 0 time = 675
* CHECK dout0_28 vdout0_28ck134 = 1.1 time = 675
* CHECK dout0_29 vdout0_29ck134 = 0 time = 675
* CHECK dout0_30 vdout0_30ck134 = 1.1 time = 675
* CHECK dout0_31 vdout0_31ck134 = 1.1 time = 675
* CHECK dout0_0 vdout0_0ck137 = 1.1 time = 690
* CHECK dout0_1 vdout0_1ck137 = 0 time = 690
* CHECK dout0_2 vdout0_2ck137 = 0 time = 690
* CHECK dout0_3 vdout0_3ck137 = 1.1 time = 690
* CHECK dout0_4 vdout0_4ck137 = 0 time = 690
* CHECK dout0_5 vdout0_5ck137 = 0 time = 690
* CHECK dout0_6 vdout0_6ck137 = 1.1 time = 690
* CHECK dout0_7 vdout0_7ck137 = 1.1 time = 690
* CHECK dout0_8 vdout0_8ck137 = 1.1 time = 690
* CHECK dout0_9 vdout0_9ck137 = 1.1 time = 690
* CHECK dout0_10 vdout0_10ck137 = 1.1 time = 690
* CHECK dout0_11 vdout0_11ck137 = 0 time = 690
* CHECK dout0_12 vdout0_12ck137 = 1.1 time = 690
* CHECK dout0_13 vdout0_13ck137 = 0 time = 690
* CHECK dout0_14 vdout0_14ck137 = 0 time = 690
* CHECK dout0_15 vdout0_15ck137 = 0 time = 690
* CHECK dout0_16 vdout0_16ck137 = 0 time = 690
* CHECK dout0_17 vdout0_17ck137 = 0 time = 690
* CHECK dout0_18 vdout0_18ck137 = 0 time = 690
* CHECK dout0_19 vdout0_19ck137 = 1.1 time = 690
* CHECK dout0_20 vdout0_20ck137 = 1.1 time = 690
* CHECK dout0_21 vdout0_21ck137 = 1.1 time = 690
* CHECK dout0_22 vdout0_22ck137 = 1.1 time = 690
* CHECK dout0_23 vdout0_23ck137 = 0 time = 690
* CHECK dout0_24 vdout0_24ck137 = 0 time = 690
* CHECK dout0_25 vdout0_25ck137 = 1.1 time = 690
* CHECK dout0_26 vdout0_26ck137 = 1.1 time = 690
* CHECK dout0_27 vdout0_27ck137 = 1.1 time = 690
* CHECK dout0_28 vdout0_28ck137 = 0 time = 690
* CHECK dout0_29 vdout0_29ck137 = 0 time = 690
* CHECK dout0_30 vdout0_30ck137 = 0 time = 690
* CHECK dout0_31 vdout0_31ck137 = 0 time = 690
* CHECK dout0_0 vdout0_0ck139 = 1.1 time = 700
* CHECK dout0_1 vdout0_1ck139 = 0 time = 700
* CHECK dout0_2 vdout0_2ck139 = 0 time = 700
* CHECK dout0_3 vdout0_3ck139 = 1.1 time = 700
* CHECK dout0_4 vdout0_4ck139 = 0 time = 700
* CHECK dout0_5 vdout0_5ck139 = 0 time = 700
* CHECK dout0_6 vdout0_6ck139 = 1.1 time = 700
* CHECK dout0_7 vdout0_7ck139 = 1.1 time = 700
* CHECK dout0_8 vdout0_8ck139 = 1.1 time = 700
* CHECK dout0_9 vdout0_9ck139 = 1.1 time = 700
* CHECK dout0_10 vdout0_10ck139 = 1.1 time = 700
* CHECK dout0_11 vdout0_11ck139 = 0 time = 700
* CHECK dout0_12 vdout0_12ck139 = 1.1 time = 700
* CHECK dout0_13 vdout0_13ck139 = 0 time = 700
* CHECK dout0_14 vdout0_14ck139 = 0 time = 700
* CHECK dout0_15 vdout0_15ck139 = 0 time = 700
* CHECK dout0_16 vdout0_16ck139 = 0 time = 700
* CHECK dout0_17 vdout0_17ck139 = 0 time = 700
* CHECK dout0_18 vdout0_18ck139 = 0 time = 700
* CHECK dout0_19 vdout0_19ck139 = 1.1 time = 700
* CHECK dout0_20 vdout0_20ck139 = 1.1 time = 700
* CHECK dout0_21 vdout0_21ck139 = 1.1 time = 700
* CHECK dout0_22 vdout0_22ck139 = 1.1 time = 700
* CHECK dout0_23 vdout0_23ck139 = 0 time = 700
* CHECK dout0_24 vdout0_24ck139 = 0 time = 700
* CHECK dout0_25 vdout0_25ck139 = 1.1 time = 700
* CHECK dout0_26 vdout0_26ck139 = 1.1 time = 700
* CHECK dout0_27 vdout0_27ck139 = 1.1 time = 700
* CHECK dout0_28 vdout0_28ck139 = 0 time = 700
* CHECK dout0_29 vdout0_29ck139 = 0 time = 700
* CHECK dout0_30 vdout0_30ck139 = 0 time = 700
* CHECK dout0_31 vdout0_31ck139 = 0 time = 700
* CHECK dout0_0 vdout0_0ck144 = 0 time = 725
* CHECK dout0_1 vdout0_1ck144 = 0 time = 725
* CHECK dout0_2 vdout0_2ck144 = 1.1 time = 725
* CHECK dout0_3 vdout0_3ck144 = 0 time = 725
* CHECK dout0_4 vdout0_4ck144 = 1.1 time = 725
* CHECK dout0_5 vdout0_5ck144 = 1.1 time = 725
* CHECK dout0_6 vdout0_6ck144 = 1.1 time = 725
* CHECK dout0_7 vdout0_7ck144 = 1.1 time = 725
* CHECK dout0_8 vdout0_8ck144 = 0 time = 725
* CHECK dout0_9 vdout0_9ck144 = 0 time = 725
* CHECK dout0_10 vdout0_10ck144 = 1.1 time = 725
* CHECK dout0_11 vdout0_11ck144 = 1.1 time = 725
* CHECK dout0_12 vdout0_12ck144 = 1.1 time = 725
* CHECK dout0_13 vdout0_13ck144 = 0 time = 725
* CHECK dout0_14 vdout0_14ck144 = 1.1 time = 725
* CHECK dout0_15 vdout0_15ck144 = 1.1 time = 725
* CHECK dout0_16 vdout0_16ck144 = 1.1 time = 725
* CHECK dout0_17 vdout0_17ck144 = 1.1 time = 725
* CHECK dout0_18 vdout0_18ck144 = 1.1 time = 725
* CHECK dout0_19 vdout0_19ck144 = 0 time = 725
* CHECK dout0_20 vdout0_20ck144 = 1.1 time = 725
* CHECK dout0_21 vdout0_21ck144 = 0 time = 725
* CHECK dout0_22 vdout0_22ck144 = 0 time = 725
* CHECK dout0_23 vdout0_23ck144 = 1.1 time = 725
* CHECK dout0_24 vdout0_24ck144 = 0 time = 725
* CHECK dout0_25 vdout0_25ck144 = 0 time = 725
* CHECK dout0_26 vdout0_26ck144 = 0 time = 725
* CHECK dout0_27 vdout0_27ck144 = 0 time = 725
* CHECK dout0_28 vdout0_28ck144 = 1.1 time = 725
* CHECK dout0_29 vdout0_29ck144 = 1.1 time = 725
* CHECK dout0_30 vdout0_30ck144 = 0 time = 725
* CHECK dout0_31 vdout0_31ck144 = 0 time = 725
* CHECK dout0_0 vdout0_0ck146 = 0 time = 735
* CHECK dout0_1 vdout0_1ck146 = 0 time = 735
* CHECK dout0_2 vdout0_2ck146 = 1.1 time = 735
* CHECK dout0_3 vdout0_3ck146 = 0 time = 735
* CHECK dout0_4 vdout0_4ck146 = 1.1 time = 735
* CHECK dout0_5 vdout0_5ck146 = 1.1 time = 735
* CHECK dout0_6 vdout0_6ck146 = 1.1 time = 735
* CHECK dout0_7 vdout0_7ck146 = 1.1 time = 735
* CHECK dout0_8 vdout0_8ck146 = 0 time = 735
* CHECK dout0_9 vdout0_9ck146 = 0 time = 735
* CHECK dout0_10 vdout0_10ck146 = 1.1 time = 735
* CHECK dout0_11 vdout0_11ck146 = 1.1 time = 735
* CHECK dout0_12 vdout0_12ck146 = 1.1 time = 735
* CHECK dout0_13 vdout0_13ck146 = 0 time = 735
* CHECK dout0_14 vdout0_14ck146 = 1.1 time = 735
* CHECK dout0_15 vdout0_15ck146 = 1.1 time = 735
* CHECK dout0_16 vdout0_16ck146 = 1.1 time = 735
* CHECK dout0_17 vdout0_17ck146 = 1.1 time = 735
* CHECK dout0_18 vdout0_18ck146 = 1.1 time = 735
* CHECK dout0_19 vdout0_19ck146 = 0 time = 735
* CHECK dout0_20 vdout0_20ck146 = 1.1 time = 735
* CHECK dout0_21 vdout0_21ck146 = 0 time = 735
* CHECK dout0_22 vdout0_22ck146 = 0 time = 735
* CHECK dout0_23 vdout0_23ck146 = 1.1 time = 735
* CHECK dout0_24 vdout0_24ck146 = 0 time = 735
* CHECK dout0_25 vdout0_25ck146 = 0 time = 735
* CHECK dout0_26 vdout0_26ck146 = 0 time = 735
* CHECK dout0_27 vdout0_27ck146 = 0 time = 735
* CHECK dout0_28 vdout0_28ck146 = 1.1 time = 735
* CHECK dout0_29 vdout0_29ck146 = 1.1 time = 735
* CHECK dout0_30 vdout0_30ck146 = 0 time = 735
* CHECK dout0_31 vdout0_31ck146 = 0 time = 735
* CHECK dout0_0 vdout0_0ck150 = 0 time = 755
* CHECK dout0_1 vdout0_1ck150 = 1.1 time = 755
* CHECK dout0_2 vdout0_2ck150 = 0 time = 755
* CHECK dout0_3 vdout0_3ck150 = 0 time = 755
* CHECK dout0_4 vdout0_4ck150 = 1.1 time = 755
* CHECK dout0_5 vdout0_5ck150 = 1.1 time = 755
* CHECK dout0_6 vdout0_6ck150 = 0 time = 755
* CHECK dout0_7 vdout0_7ck150 = 0 time = 755
* CHECK dout0_8 vdout0_8ck150 = 1.1 time = 755
* CHECK dout0_9 vdout0_9ck150 = 1.1 time = 755
* CHECK dout0_10 vdout0_10ck150 = 0 time = 755
* CHECK dout0_11 vdout0_11ck150 = 1.1 time = 755
* CHECK dout0_12 vdout0_12ck150 = 0 time = 755
* CHECK dout0_13 vdout0_13ck150 = 0 time = 755
* CHECK dout0_14 vdout0_14ck150 = 1.1 time = 755
* CHECK dout0_15 vdout0_15ck150 = 0 time = 755
* CHECK dout0_16 vdout0_16ck150 = 1.1 time = 755
* CHECK dout0_17 vdout0_17ck150 = 0 time = 755
* CHECK dout0_18 vdout0_18ck150 = 1.1 time = 755
* CHECK dout0_19 vdout0_19ck150 = 0 time = 755
* CHECK dout0_20 vdout0_20ck150 = 0 time = 755
* CHECK dout0_21 vdout0_21ck150 = 1.1 time = 755
* CHECK dout0_22 vdout0_22ck150 = 1.1 time = 755
* CHECK dout0_23 vdout0_23ck150 = 0 time = 755
* CHECK dout0_24 vdout0_24ck150 = 1.1 time = 755
* CHECK dout0_25 vdout0_25ck150 = 1.1 time = 755
* CHECK dout0_26 vdout0_26ck150 = 0 time = 755
* CHECK dout0_27 vdout0_27ck150 = 0 time = 755
* CHECK dout0_28 vdout0_28ck150 = 0 time = 755
* CHECK dout0_29 vdout0_29ck150 = 0 time = 755
* CHECK dout0_30 vdout0_30ck150 = 1.1 time = 755
* CHECK dout0_31 vdout0_31ck150 = 0 time = 755
* CHECK dout0_0 vdout0_0ck151 = 1.1 time = 760
* CHECK dout0_1 vdout0_1ck151 = 0 time = 760
* CHECK dout0_2 vdout0_2ck151 = 1.1 time = 760
* CHECK dout0_3 vdout0_3ck151 = 1.1 time = 760
* CHECK dout0_4 vdout0_4ck151 = 1.1 time = 760
* CHECK dout0_5 vdout0_5ck151 = 0 time = 760
* CHECK dout0_6 vdout0_6ck151 = 0 time = 760
* CHECK dout0_7 vdout0_7ck151 = 1.1 time = 760
* CHECK dout0_8 vdout0_8ck151 = 0 time = 760
* CHECK dout0_9 vdout0_9ck151 = 0 time = 760
* CHECK dout0_10 vdout0_10ck151 = 1.1 time = 760
* CHECK dout0_11 vdout0_11ck151 = 1.1 time = 760
* CHECK dout0_12 vdout0_12ck151 = 1.1 time = 760
* CHECK dout0_13 vdout0_13ck151 = 0 time = 760
* CHECK dout0_14 vdout0_14ck151 = 0 time = 760
* CHECK dout0_15 vdout0_15ck151 = 1.1 time = 760
* CHECK dout0_16 vdout0_16ck151 = 0 time = 760
* CHECK dout0_17 vdout0_17ck151 = 1.1 time = 760
* CHECK dout0_18 vdout0_18ck151 = 1.1 time = 760
* CHECK dout0_19 vdout0_19ck151 = 1.1 time = 760
* CHECK dout0_20 vdout0_20ck151 = 0 time = 760
* CHECK dout0_21 vdout0_21ck151 = 0 time = 760
* CHECK dout0_22 vdout0_22ck151 = 0 time = 760
* CHECK dout0_23 vdout0_23ck151 = 1.1 time = 760
* CHECK dout0_24 vdout0_24ck151 = 1.1 time = 760
* CHECK dout0_25 vdout0_25ck151 = 0 time = 760
* CHECK dout0_26 vdout0_26ck151 = 0 time = 760
* CHECK dout0_27 vdout0_27ck151 = 0 time = 760
* CHECK dout0_28 vdout0_28ck151 = 0 time = 760
* CHECK dout0_29 vdout0_29ck151 = 1.1 time = 760
* CHECK dout0_30 vdout0_30ck151 = 1.1 time = 760
* CHECK dout0_31 vdout0_31ck151 = 0 time = 760
* CHECK dout0_0 vdout0_0ck152 = 1.1 time = 765
* CHECK dout0_1 vdout0_1ck152 = 1.1 time = 765
* CHECK dout0_2 vdout0_2ck152 = 1.1 time = 765
* CHECK dout0_3 vdout0_3ck152 = 0 time = 765
* CHECK dout0_4 vdout0_4ck152 = 0 time = 765
* CHECK dout0_5 vdout0_5ck152 = 1.1 time = 765
* CHECK dout0_6 vdout0_6ck152 = 0 time = 765
* CHECK dout0_7 vdout0_7ck152 = 0 time = 765
* CHECK dout0_8 vdout0_8ck152 = 1.1 time = 765
* CHECK dout0_9 vdout0_9ck152 = 0 time = 765
* CHECK dout0_10 vdout0_10ck152 = 0 time = 765
* CHECK dout0_11 vdout0_11ck152 = 1.1 time = 765
* CHECK dout0_12 vdout0_12ck152 = 0 time = 765
* CHECK dout0_13 vdout0_13ck152 = 1.1 time = 765
* CHECK dout0_14 vdout0_14ck152 = 1.1 time = 765
* CHECK dout0_15 vdout0_15ck152 = 0 time = 765
* CHECK dout0_16 vdout0_16ck152 = 0 time = 765
* CHECK dout0_17 vdout0_17ck152 = 0 time = 765
* CHECK dout0_18 vdout0_18ck152 = 0 time = 765
* CHECK dout0_19 vdout0_19ck152 = 1.1 time = 765
* CHECK dout0_20 vdout0_20ck152 = 1.1 time = 765
* CHECK dout0_21 vdout0_21ck152 = 0 time = 765
* CHECK dout0_22 vdout0_22ck152 = 1.1 time = 765
* CHECK dout0_23 vdout0_23ck152 = 1.1 time = 765
* CHECK dout0_24 vdout0_24ck152 = 0 time = 765
* CHECK dout0_25 vdout0_25ck152 = 1.1 time = 765
* CHECK dout0_26 vdout0_26ck152 = 1.1 time = 765
* CHECK dout0_27 vdout0_27ck152 = 1.1 time = 765
* CHECK dout0_28 vdout0_28ck152 = 1.1 time = 765
* CHECK dout0_29 vdout0_29ck152 = 1.1 time = 765
* CHECK dout0_30 vdout0_30ck152 = 0 time = 765
* CHECK dout0_31 vdout0_31ck152 = 0 time = 765
* CHECK dout0_0 vdout0_0ck153 = 1.1 time = 770
* CHECK dout0_1 vdout0_1ck153 = 0 time = 770
* CHECK dout0_2 vdout0_2ck153 = 0 time = 770
* CHECK dout0_3 vdout0_3ck153 = 1.1 time = 770
* CHECK dout0_4 vdout0_4ck153 = 0 time = 770
* CHECK dout0_5 vdout0_5ck153 = 0 time = 770
* CHECK dout0_6 vdout0_6ck153 = 0 time = 770
* CHECK dout0_7 vdout0_7ck153 = 0 time = 770
* CHECK dout0_8 vdout0_8ck153 = 0 time = 770
* CHECK dout0_9 vdout0_9ck153 = 0 time = 770
* CHECK dout0_10 vdout0_10ck153 = 1.1 time = 770
* CHECK dout0_11 vdout0_11ck153 = 0 time = 770
* CHECK dout0_12 vdout0_12ck153 = 1.1 time = 770
* CHECK dout0_13 vdout0_13ck153 = 1.1 time = 770
* CHECK dout0_14 vdout0_14ck153 = 1.1 time = 770
* CHECK dout0_15 vdout0_15ck153 = 1.1 time = 770
* CHECK dout0_16 vdout0_16ck153 = 0 time = 770
* CHECK dout0_17 vdout0_17ck153 = 0 time = 770
* CHECK dout0_18 vdout0_18ck153 = 1.1 time = 770
* CHECK dout0_19 vdout0_19ck153 = 0 time = 770
* CHECK dout0_20 vdout0_20ck153 = 0 time = 770
* CHECK dout0_21 vdout0_21ck153 = 1.1 time = 770
* CHECK dout0_22 vdout0_22ck153 = 1.1 time = 770
* CHECK dout0_23 vdout0_23ck153 = 1.1 time = 770
* CHECK dout0_24 vdout0_24ck153 = 0 time = 770
* CHECK dout0_25 vdout0_25ck153 = 1.1 time = 770
* CHECK dout0_26 vdout0_26ck153 = 1.1 time = 770
* CHECK dout0_27 vdout0_27ck153 = 0 time = 770
* CHECK dout0_28 vdout0_28ck153 = 0 time = 770
* CHECK dout0_29 vdout0_29ck153 = 1.1 time = 770
* CHECK dout0_30 vdout0_30ck153 = 1.1 time = 770
* CHECK dout0_31 vdout0_31ck153 = 0 time = 770
* CHECK dout0_0 vdout0_0ck154 = 1.1 time = 775
* CHECK dout0_1 vdout0_1ck154 = 0 time = 775
* CHECK dout0_2 vdout0_2ck154 = 1.1 time = 775
* CHECK dout0_3 vdout0_3ck154 = 1.1 time = 775
* CHECK dout0_4 vdout0_4ck154 = 1.1 time = 775
* CHECK dout0_5 vdout0_5ck154 = 0 time = 775
* CHECK dout0_6 vdout0_6ck154 = 0 time = 775
* CHECK dout0_7 vdout0_7ck154 = 1.1 time = 775
* CHECK dout0_8 vdout0_8ck154 = 0 time = 775
* CHECK dout0_9 vdout0_9ck154 = 0 time = 775
* CHECK dout0_10 vdout0_10ck154 = 1.1 time = 775
* CHECK dout0_11 vdout0_11ck154 = 1.1 time = 775
* CHECK dout0_12 vdout0_12ck154 = 1.1 time = 775
* CHECK dout0_13 vdout0_13ck154 = 0 time = 775
* CHECK dout0_14 vdout0_14ck154 = 0 time = 775
* CHECK dout0_15 vdout0_15ck154 = 1.1 time = 775
* CHECK dout0_16 vdout0_16ck154 = 0 time = 775
* CHECK dout0_17 vdout0_17ck154 = 1.1 time = 775
* CHECK dout0_18 vdout0_18ck154 = 1.1 time = 775
* CHECK dout0_19 vdout0_19ck154 = 1.1 time = 775
* CHECK dout0_20 vdout0_20ck154 = 0 time = 775
* CHECK dout0_21 vdout0_21ck154 = 0 time = 775
* CHECK dout0_22 vdout0_22ck154 = 0 time = 775
* CHECK dout0_23 vdout0_23ck154 = 1.1 time = 775
* CHECK dout0_24 vdout0_24ck154 = 1.1 time = 775
* CHECK dout0_25 vdout0_25ck154 = 0 time = 775
* CHECK dout0_26 vdout0_26ck154 = 0 time = 775
* CHECK dout0_27 vdout0_27ck154 = 0 time = 775
* CHECK dout0_28 vdout0_28ck154 = 0 time = 775
* CHECK dout0_29 vdout0_29ck154 = 1.1 time = 775
* CHECK dout0_30 vdout0_30ck154 = 1.1 time = 775
* CHECK dout0_31 vdout0_31ck154 = 0 time = 775
* CHECK dout0_0 vdout0_0ck156 = 1.1 time = 785
* CHECK dout0_1 vdout0_1ck156 = 0 time = 785
* CHECK dout0_2 vdout0_2ck156 = 0 time = 785
* CHECK dout0_3 vdout0_3ck156 = 1.1 time = 785
* CHECK dout0_4 vdout0_4ck156 = 0 time = 785
* CHECK dout0_5 vdout0_5ck156 = 0 time = 785
* CHECK dout0_6 vdout0_6ck156 = 0 time = 785
* CHECK dout0_7 vdout0_7ck156 = 0 time = 785
* CHECK dout0_8 vdout0_8ck156 = 0 time = 785
* CHECK dout0_9 vdout0_9ck156 = 0 time = 785
* CHECK dout0_10 vdout0_10ck156 = 1.1 time = 785
* CHECK dout0_11 vdout0_11ck156 = 0 time = 785
* CHECK dout0_12 vdout0_12ck156 = 1.1 time = 785
* CHECK dout0_13 vdout0_13ck156 = 1.1 time = 785
* CHECK dout0_14 vdout0_14ck156 = 1.1 time = 785
* CHECK dout0_15 vdout0_15ck156 = 1.1 time = 785
* CHECK dout0_16 vdout0_16ck156 = 0 time = 785
* CHECK dout0_17 vdout0_17ck156 = 0 time = 785
* CHECK dout0_18 vdout0_18ck156 = 1.1 time = 785
* CHECK dout0_19 vdout0_19ck156 = 0 time = 785
* CHECK dout0_20 vdout0_20ck156 = 0 time = 785
* CHECK dout0_21 vdout0_21ck156 = 1.1 time = 785
* CHECK dout0_22 vdout0_22ck156 = 1.1 time = 785
* CHECK dout0_23 vdout0_23ck156 = 1.1 time = 785
* CHECK dout0_24 vdout0_24ck156 = 0 time = 785
* CHECK dout0_25 vdout0_25ck156 = 1.1 time = 785
* CHECK dout0_26 vdout0_26ck156 = 1.1 time = 785
* CHECK dout0_27 vdout0_27ck156 = 0 time = 785
* CHECK dout0_28 vdout0_28ck156 = 0 time = 785
* CHECK dout0_29 vdout0_29ck156 = 1.1 time = 785
* CHECK dout0_30 vdout0_30ck156 = 1.1 time = 785
* CHECK dout0_31 vdout0_31ck156 = 0 time = 785
* CHECK dout0_0 vdout0_0ck157 = 1.1 time = 790
* CHECK dout0_1 vdout0_1ck157 = 1.1 time = 790
* CHECK dout0_2 vdout0_2ck157 = 1.1 time = 790
* CHECK dout0_3 vdout0_3ck157 = 0 time = 790
* CHECK dout0_4 vdout0_4ck157 = 0 time = 790
* CHECK dout0_5 vdout0_5ck157 = 1.1 time = 790
* CHECK dout0_6 vdout0_6ck157 = 0 time = 790
* CHECK dout0_7 vdout0_7ck157 = 0 time = 790
* CHECK dout0_8 vdout0_8ck157 = 1.1 time = 790
* CHECK dout0_9 vdout0_9ck157 = 0 time = 790
* CHECK dout0_10 vdout0_10ck157 = 0 time = 790
* CHECK dout0_11 vdout0_11ck157 = 1.1 time = 790
* CHECK dout0_12 vdout0_12ck157 = 0 time = 790
* CHECK dout0_13 vdout0_13ck157 = 1.1 time = 790
* CHECK dout0_14 vdout0_14ck157 = 1.1 time = 790
* CHECK dout0_15 vdout0_15ck157 = 0 time = 790
* CHECK dout0_16 vdout0_16ck157 = 0 time = 790
* CHECK dout0_17 vdout0_17ck157 = 0 time = 790
* CHECK dout0_18 vdout0_18ck157 = 0 time = 790
* CHECK dout0_19 vdout0_19ck157 = 1.1 time = 790
* CHECK dout0_20 vdout0_20ck157 = 1.1 time = 790
* CHECK dout0_21 vdout0_21ck157 = 0 time = 790
* CHECK dout0_22 vdout0_22ck157 = 1.1 time = 790
* CHECK dout0_23 vdout0_23ck157 = 1.1 time = 790
* CHECK dout0_24 vdout0_24ck157 = 0 time = 790
* CHECK dout0_25 vdout0_25ck157 = 1.1 time = 790
* CHECK dout0_26 vdout0_26ck157 = 1.1 time = 790
* CHECK dout0_27 vdout0_27ck157 = 1.1 time = 790
* CHECK dout0_28 vdout0_28ck157 = 1.1 time = 790
* CHECK dout0_29 vdout0_29ck157 = 1.1 time = 790
* CHECK dout0_30 vdout0_30ck157 = 0 time = 790
* CHECK dout0_31 vdout0_31ck157 = 0 time = 790
* CHECK dout0_0 vdout0_0ck158 = 0 time = 795
* CHECK dout0_1 vdout0_1ck158 = 1.1 time = 795
* CHECK dout0_2 vdout0_2ck158 = 0 time = 795
* CHECK dout0_3 vdout0_3ck158 = 0 time = 795
* CHECK dout0_4 vdout0_4ck158 = 1.1 time = 795
* CHECK dout0_5 vdout0_5ck158 = 1.1 time = 795
* CHECK dout0_6 vdout0_6ck158 = 0 time = 795
* CHECK dout0_7 vdout0_7ck158 = 0 time = 795
* CHECK dout0_8 vdout0_8ck158 = 1.1 time = 795
* CHECK dout0_9 vdout0_9ck158 = 1.1 time = 795
* CHECK dout0_10 vdout0_10ck158 = 0 time = 795
* CHECK dout0_11 vdout0_11ck158 = 1.1 time = 795
* CHECK dout0_12 vdout0_12ck158 = 0 time = 795
* CHECK dout0_13 vdout0_13ck158 = 0 time = 795
* CHECK dout0_14 vdout0_14ck158 = 1.1 time = 795
* CHECK dout0_15 vdout0_15ck158 = 0 time = 795
* CHECK dout0_16 vdout0_16ck158 = 1.1 time = 795
* CHECK dout0_17 vdout0_17ck158 = 0 time = 795
* CHECK dout0_18 vdout0_18ck158 = 1.1 time = 795
* CHECK dout0_19 vdout0_19ck158 = 0 time = 795
* CHECK dout0_20 vdout0_20ck158 = 0 time = 795
* CHECK dout0_21 vdout0_21ck158 = 1.1 time = 795
* CHECK dout0_22 vdout0_22ck158 = 1.1 time = 795
* CHECK dout0_23 vdout0_23ck158 = 0 time = 795
* CHECK dout0_24 vdout0_24ck158 = 1.1 time = 795
* CHECK dout0_25 vdout0_25ck158 = 1.1 time = 795
* CHECK dout0_26 vdout0_26ck158 = 0 time = 795
* CHECK dout0_27 vdout0_27ck158 = 0 time = 795
* CHECK dout0_28 vdout0_28ck158 = 0 time = 795
* CHECK dout0_29 vdout0_29ck158 = 0 time = 795
* CHECK dout0_30 vdout0_30ck158 = 1.1 time = 795
* CHECK dout0_31 vdout0_31ck158 = 0 time = 795
* CHECK dout0_0 vdout0_0ck162 = 1.1 time = 815
* CHECK dout0_1 vdout0_1ck162 = 1.1 time = 815
* CHECK dout0_2 vdout0_2ck162 = 1.1 time = 815
* CHECK dout0_3 vdout0_3ck162 = 0 time = 815
* CHECK dout0_4 vdout0_4ck162 = 0 time = 815
* CHECK dout0_5 vdout0_5ck162 = 1.1 time = 815
* CHECK dout0_6 vdout0_6ck162 = 0 time = 815
* CHECK dout0_7 vdout0_7ck162 = 0 time = 815
* CHECK dout0_8 vdout0_8ck162 = 1.1 time = 815
* CHECK dout0_9 vdout0_9ck162 = 0 time = 815
* CHECK dout0_10 vdout0_10ck162 = 0 time = 815
* CHECK dout0_11 vdout0_11ck162 = 1.1 time = 815
* CHECK dout0_12 vdout0_12ck162 = 0 time = 815
* CHECK dout0_13 vdout0_13ck162 = 1.1 time = 815
* CHECK dout0_14 vdout0_14ck162 = 1.1 time = 815
* CHECK dout0_15 vdout0_15ck162 = 0 time = 815
* CHECK dout0_16 vdout0_16ck162 = 0 time = 815
* CHECK dout0_17 vdout0_17ck162 = 0 time = 815
* CHECK dout0_18 vdout0_18ck162 = 0 time = 815
* CHECK dout0_19 vdout0_19ck162 = 1.1 time = 815
* CHECK dout0_20 vdout0_20ck162 = 1.1 time = 815
* CHECK dout0_21 vdout0_21ck162 = 0 time = 815
* CHECK dout0_22 vdout0_22ck162 = 1.1 time = 815
* CHECK dout0_23 vdout0_23ck162 = 1.1 time = 815
* CHECK dout0_24 vdout0_24ck162 = 0 time = 815
* CHECK dout0_25 vdout0_25ck162 = 1.1 time = 815
* CHECK dout0_26 vdout0_26ck162 = 1.1 time = 815
* CHECK dout0_27 vdout0_27ck162 = 1.1 time = 815
* CHECK dout0_28 vdout0_28ck162 = 1.1 time = 815
* CHECK dout0_29 vdout0_29ck162 = 1.1 time = 815
* CHECK dout0_30 vdout0_30ck162 = 0 time = 815
* CHECK dout0_31 vdout0_31ck162 = 0 time = 815
* CHECK dout0_0 vdout0_0ck163 = 1.1 time = 820
* CHECK dout0_1 vdout0_1ck163 = 0 time = 820
* CHECK dout0_2 vdout0_2ck163 = 0 time = 820
* CHECK dout0_3 vdout0_3ck163 = 1.1 time = 820
* CHECK dout0_4 vdout0_4ck163 = 0 time = 820
* CHECK dout0_5 vdout0_5ck163 = 0 time = 820
* CHECK dout0_6 vdout0_6ck163 = 0 time = 820
* CHECK dout0_7 vdout0_7ck163 = 0 time = 820
* CHECK dout0_8 vdout0_8ck163 = 0 time = 820
* CHECK dout0_9 vdout0_9ck163 = 0 time = 820
* CHECK dout0_10 vdout0_10ck163 = 1.1 time = 820
* CHECK dout0_11 vdout0_11ck163 = 0 time = 820
* CHECK dout0_12 vdout0_12ck163 = 1.1 time = 820
* CHECK dout0_13 vdout0_13ck163 = 1.1 time = 820
* CHECK dout0_14 vdout0_14ck163 = 1.1 time = 820
* CHECK dout0_15 vdout0_15ck163 = 1.1 time = 820
* CHECK dout0_16 vdout0_16ck163 = 0 time = 820
* CHECK dout0_17 vdout0_17ck163 = 0 time = 820
* CHECK dout0_18 vdout0_18ck163 = 1.1 time = 820
* CHECK dout0_19 vdout0_19ck163 = 0 time = 820
* CHECK dout0_20 vdout0_20ck163 = 0 time = 820
* CHECK dout0_21 vdout0_21ck163 = 1.1 time = 820
* CHECK dout0_22 vdout0_22ck163 = 1.1 time = 820
* CHECK dout0_23 vdout0_23ck163 = 1.1 time = 820
* CHECK dout0_24 vdout0_24ck163 = 0 time = 820
* CHECK dout0_25 vdout0_25ck163 = 1.1 time = 820
* CHECK dout0_26 vdout0_26ck163 = 1.1 time = 820
* CHECK dout0_27 vdout0_27ck163 = 0 time = 820
* CHECK dout0_28 vdout0_28ck163 = 0 time = 820
* CHECK dout0_29 vdout0_29ck163 = 1.1 time = 820
* CHECK dout0_30 vdout0_30ck163 = 1.1 time = 820
* CHECK dout0_31 vdout0_31ck163 = 0 time = 820
* CHECK dout0_0 vdout0_0ck164 = 0 time = 825
* CHECK dout0_1 vdout0_1ck164 = 0 time = 825
* CHECK dout0_2 vdout0_2ck164 = 1.1 time = 825
* CHECK dout0_3 vdout0_3ck164 = 0 time = 825
* CHECK dout0_4 vdout0_4ck164 = 1.1 time = 825
* CHECK dout0_5 vdout0_5ck164 = 1.1 time = 825
* CHECK dout0_6 vdout0_6ck164 = 1.1 time = 825
* CHECK dout0_7 vdout0_7ck164 = 1.1 time = 825
* CHECK dout0_8 vdout0_8ck164 = 0 time = 825
* CHECK dout0_9 vdout0_9ck164 = 0 time = 825
* CHECK dout0_10 vdout0_10ck164 = 1.1 time = 825
* CHECK dout0_11 vdout0_11ck164 = 1.1 time = 825
* CHECK dout0_12 vdout0_12ck164 = 1.1 time = 825
* CHECK dout0_13 vdout0_13ck164 = 0 time = 825
* CHECK dout0_14 vdout0_14ck164 = 1.1 time = 825
* CHECK dout0_15 vdout0_15ck164 = 1.1 time = 825
* CHECK dout0_16 vdout0_16ck164 = 1.1 time = 825
* CHECK dout0_17 vdout0_17ck164 = 1.1 time = 825
* CHECK dout0_18 vdout0_18ck164 = 1.1 time = 825
* CHECK dout0_19 vdout0_19ck164 = 0 time = 825
* CHECK dout0_20 vdout0_20ck164 = 1.1 time = 825
* CHECK dout0_21 vdout0_21ck164 = 0 time = 825
* CHECK dout0_22 vdout0_22ck164 = 0 time = 825
* CHECK dout0_23 vdout0_23ck164 = 1.1 time = 825
* CHECK dout0_24 vdout0_24ck164 = 0 time = 825
* CHECK dout0_25 vdout0_25ck164 = 0 time = 825
* CHECK dout0_26 vdout0_26ck164 = 0 time = 825
* CHECK dout0_27 vdout0_27ck164 = 0 time = 825
* CHECK dout0_28 vdout0_28ck164 = 1.1 time = 825
* CHECK dout0_29 vdout0_29ck164 = 1.1 time = 825
* CHECK dout0_30 vdout0_30ck164 = 0 time = 825
* CHECK dout0_31 vdout0_31ck164 = 0 time = 825
* CHECK dout0_0 vdout0_0ck166 = 0 time = 835
* CHECK dout0_1 vdout0_1ck166 = 0 time = 835
* CHECK dout0_2 vdout0_2ck166 = 0 time = 835
* CHECK dout0_3 vdout0_3ck166 = 1.1 time = 835
* CHECK dout0_4 vdout0_4ck166 = 0 time = 835
* CHECK dout0_5 vdout0_5ck166 = 0 time = 835
* CHECK dout0_6 vdout0_6ck166 = 1.1 time = 835
* CHECK dout0_7 vdout0_7ck166 = 1.1 time = 835
* CHECK dout0_8 vdout0_8ck166 = 0 time = 835
* CHECK dout0_9 vdout0_9ck166 = 0 time = 835
* CHECK dout0_10 vdout0_10ck166 = 0 time = 835
* CHECK dout0_11 vdout0_11ck166 = 0 time = 835
* CHECK dout0_12 vdout0_12ck166 = 1.1 time = 835
* CHECK dout0_13 vdout0_13ck166 = 1.1 time = 835
* CHECK dout0_14 vdout0_14ck166 = 0 time = 835
* CHECK dout0_15 vdout0_15ck166 = 0 time = 835
* CHECK dout0_16 vdout0_16ck166 = 0 time = 835
* CHECK dout0_17 vdout0_17ck166 = 0 time = 835
* CHECK dout0_18 vdout0_18ck166 = 1.1 time = 835
* CHECK dout0_19 vdout0_19ck166 = 1.1 time = 835
* CHECK dout0_20 vdout0_20ck166 = 1.1 time = 835
* CHECK dout0_21 vdout0_21ck166 = 1.1 time = 835
* CHECK dout0_22 vdout0_22ck166 = 0 time = 835
* CHECK dout0_23 vdout0_23ck166 = 0 time = 835
* CHECK dout0_24 vdout0_24ck166 = 1.1 time = 835
* CHECK dout0_25 vdout0_25ck166 = 1.1 time = 835
* CHECK dout0_26 vdout0_26ck166 = 1.1 time = 835
* CHECK dout0_27 vdout0_27ck166 = 0 time = 835
* CHECK dout0_28 vdout0_28ck166 = 1.1 time = 835
* CHECK dout0_29 vdout0_29ck166 = 1.1 time = 835
* CHECK dout0_30 vdout0_30ck166 = 0 time = 835
* CHECK dout0_31 vdout0_31ck166 = 1.1 time = 835
* CHECK dout0_0 vdout0_0ck167 = 1.1 time = 840
* CHECK dout0_1 vdout0_1ck167 = 0 time = 840
* CHECK dout0_2 vdout0_2ck167 = 1.1 time = 840
* CHECK dout0_3 vdout0_3ck167 = 1.1 time = 840
* CHECK dout0_4 vdout0_4ck167 = 1.1 time = 840
* CHECK dout0_5 vdout0_5ck167 = 0 time = 840
* CHECK dout0_6 vdout0_6ck167 = 0 time = 840
* CHECK dout0_7 vdout0_7ck167 = 1.1 time = 840
* CHECK dout0_8 vdout0_8ck167 = 0 time = 840
* CHECK dout0_9 vdout0_9ck167 = 0 time = 840
* CHECK dout0_10 vdout0_10ck167 = 1.1 time = 840
* CHECK dout0_11 vdout0_11ck167 = 1.1 time = 840
* CHECK dout0_12 vdout0_12ck167 = 1.1 time = 840
* CHECK dout0_13 vdout0_13ck167 = 0 time = 840
* CHECK dout0_14 vdout0_14ck167 = 0 time = 840
* CHECK dout0_15 vdout0_15ck167 = 1.1 time = 840
* CHECK dout0_16 vdout0_16ck167 = 0 time = 840
* CHECK dout0_17 vdout0_17ck167 = 1.1 time = 840
* CHECK dout0_18 vdout0_18ck167 = 1.1 time = 840
* CHECK dout0_19 vdout0_19ck167 = 1.1 time = 840
* CHECK dout0_20 vdout0_20ck167 = 0 time = 840
* CHECK dout0_21 vdout0_21ck167 = 0 time = 840
* CHECK dout0_22 vdout0_22ck167 = 0 time = 840
* CHECK dout0_23 vdout0_23ck167 = 1.1 time = 840
* CHECK dout0_24 vdout0_24ck167 = 1.1 time = 840
* CHECK dout0_25 vdout0_25ck167 = 0 time = 840
* CHECK dout0_26 vdout0_26ck167 = 0 time = 840
* CHECK dout0_27 vdout0_27ck167 = 0 time = 840
* CHECK dout0_28 vdout0_28ck167 = 0 time = 840
* CHECK dout0_29 vdout0_29ck167 = 1.1 time = 840
* CHECK dout0_30 vdout0_30ck167 = 1.1 time = 840
* CHECK dout0_31 vdout0_31ck167 = 0 time = 840
* CHECK dout0_0 vdout0_0ck171 = 1.1 time = 860
* CHECK dout0_1 vdout0_1ck171 = 0 time = 860
* CHECK dout0_2 vdout0_2ck171 = 1.1 time = 860
* CHECK dout0_3 vdout0_3ck171 = 1.1 time = 860
* CHECK dout0_4 vdout0_4ck171 = 1.1 time = 860
* CHECK dout0_5 vdout0_5ck171 = 0 time = 860
* CHECK dout0_6 vdout0_6ck171 = 0 time = 860
* CHECK dout0_7 vdout0_7ck171 = 1.1 time = 860
* CHECK dout0_8 vdout0_8ck171 = 0 time = 860
* CHECK dout0_9 vdout0_9ck171 = 0 time = 860
* CHECK dout0_10 vdout0_10ck171 = 1.1 time = 860
* CHECK dout0_11 vdout0_11ck171 = 1.1 time = 860
* CHECK dout0_12 vdout0_12ck171 = 1.1 time = 860
* CHECK dout0_13 vdout0_13ck171 = 0 time = 860
* CHECK dout0_14 vdout0_14ck171 = 0 time = 860
* CHECK dout0_15 vdout0_15ck171 = 1.1 time = 860
* CHECK dout0_16 vdout0_16ck171 = 0 time = 860
* CHECK dout0_17 vdout0_17ck171 = 1.1 time = 860
* CHECK dout0_18 vdout0_18ck171 = 1.1 time = 860
* CHECK dout0_19 vdout0_19ck171 = 1.1 time = 860
* CHECK dout0_20 vdout0_20ck171 = 0 time = 860
* CHECK dout0_21 vdout0_21ck171 = 0 time = 860
* CHECK dout0_22 vdout0_22ck171 = 0 time = 860
* CHECK dout0_23 vdout0_23ck171 = 1.1 time = 860
* CHECK dout0_24 vdout0_24ck171 = 1.1 time = 860
* CHECK dout0_25 vdout0_25ck171 = 0 time = 860
* CHECK dout0_26 vdout0_26ck171 = 0 time = 860
* CHECK dout0_27 vdout0_27ck171 = 0 time = 860
* CHECK dout0_28 vdout0_28ck171 = 0 time = 860
* CHECK dout0_29 vdout0_29ck171 = 1.1 time = 860
* CHECK dout0_30 vdout0_30ck171 = 1.1 time = 860
* CHECK dout0_31 vdout0_31ck171 = 0 time = 860
* CHECK dout0_0 vdout0_0ck172 = 1.1 time = 865
* CHECK dout0_1 vdout0_1ck172 = 1.1 time = 865
* CHECK dout0_2 vdout0_2ck172 = 1.1 time = 865
* CHECK dout0_3 vdout0_3ck172 = 0 time = 865
* CHECK dout0_4 vdout0_4ck172 = 0 time = 865
* CHECK dout0_5 vdout0_5ck172 = 1.1 time = 865
* CHECK dout0_6 vdout0_6ck172 = 0 time = 865
* CHECK dout0_7 vdout0_7ck172 = 0 time = 865
* CHECK dout0_8 vdout0_8ck172 = 1.1 time = 865
* CHECK dout0_9 vdout0_9ck172 = 0 time = 865
* CHECK dout0_10 vdout0_10ck172 = 0 time = 865
* CHECK dout0_11 vdout0_11ck172 = 1.1 time = 865
* CHECK dout0_12 vdout0_12ck172 = 0 time = 865
* CHECK dout0_13 vdout0_13ck172 = 1.1 time = 865
* CHECK dout0_14 vdout0_14ck172 = 1.1 time = 865
* CHECK dout0_15 vdout0_15ck172 = 0 time = 865
* CHECK dout0_16 vdout0_16ck172 = 0 time = 865
* CHECK dout0_17 vdout0_17ck172 = 0 time = 865
* CHECK dout0_18 vdout0_18ck172 = 0 time = 865
* CHECK dout0_19 vdout0_19ck172 = 1.1 time = 865
* CHECK dout0_20 vdout0_20ck172 = 1.1 time = 865
* CHECK dout0_21 vdout0_21ck172 = 0 time = 865
* CHECK dout0_22 vdout0_22ck172 = 1.1 time = 865
* CHECK dout0_23 vdout0_23ck172 = 1.1 time = 865
* CHECK dout0_24 vdout0_24ck172 = 0 time = 865
* CHECK dout0_25 vdout0_25ck172 = 1.1 time = 865
* CHECK dout0_26 vdout0_26ck172 = 1.1 time = 865
* CHECK dout0_27 vdout0_27ck172 = 1.1 time = 865
* CHECK dout0_28 vdout0_28ck172 = 1.1 time = 865
* CHECK dout0_29 vdout0_29ck172 = 1.1 time = 865
* CHECK dout0_30 vdout0_30ck172 = 0 time = 865
* CHECK dout0_31 vdout0_31ck172 = 0 time = 865
* CHECK dout0_0 vdout0_0ck173 = 0 time = 870
* CHECK dout0_1 vdout0_1ck173 = 0 time = 870
* CHECK dout0_2 vdout0_2ck173 = 1.1 time = 870
* CHECK dout0_3 vdout0_3ck173 = 0 time = 870
* CHECK dout0_4 vdout0_4ck173 = 1.1 time = 870
* CHECK dout0_5 vdout0_5ck173 = 1.1 time = 870
* CHECK dout0_6 vdout0_6ck173 = 1.1 time = 870
* CHECK dout0_7 vdout0_7ck173 = 1.1 time = 870
* CHECK dout0_8 vdout0_8ck173 = 0 time = 870
* CHECK dout0_9 vdout0_9ck173 = 0 time = 870
* CHECK dout0_10 vdout0_10ck173 = 1.1 time = 870
* CHECK dout0_11 vdout0_11ck173 = 1.1 time = 870
* CHECK dout0_12 vdout0_12ck173 = 1.1 time = 870
* CHECK dout0_13 vdout0_13ck173 = 0 time = 870
* CHECK dout0_14 vdout0_14ck173 = 1.1 time = 870
* CHECK dout0_15 vdout0_15ck173 = 1.1 time = 870
* CHECK dout0_16 vdout0_16ck173 = 1.1 time = 870
* CHECK dout0_17 vdout0_17ck173 = 1.1 time = 870
* CHECK dout0_18 vdout0_18ck173 = 1.1 time = 870
* CHECK dout0_19 vdout0_19ck173 = 0 time = 870
* CHECK dout0_20 vdout0_20ck173 = 1.1 time = 870
* CHECK dout0_21 vdout0_21ck173 = 0 time = 870
* CHECK dout0_22 vdout0_22ck173 = 0 time = 870
* CHECK dout0_23 vdout0_23ck173 = 1.1 time = 870
* CHECK dout0_24 vdout0_24ck173 = 0 time = 870
* CHECK dout0_25 vdout0_25ck173 = 0 time = 870
* CHECK dout0_26 vdout0_26ck173 = 0 time = 870
* CHECK dout0_27 vdout0_27ck173 = 0 time = 870
* CHECK dout0_28 vdout0_28ck173 = 1.1 time = 870
* CHECK dout0_29 vdout0_29ck173 = 1.1 time = 870
* CHECK dout0_30 vdout0_30ck173 = 0 time = 870
* CHECK dout0_31 vdout0_31ck173 = 0 time = 870
* CHECK dout0_0 vdout0_0ck175 = 0 time = 880
* CHECK dout0_1 vdout0_1ck175 = 0 time = 880
* CHECK dout0_2 vdout0_2ck175 = 0 time = 880
* CHECK dout0_3 vdout0_3ck175 = 1.1 time = 880
* CHECK dout0_4 vdout0_4ck175 = 0 time = 880
* CHECK dout0_5 vdout0_5ck175 = 0 time = 880
* CHECK dout0_6 vdout0_6ck175 = 1.1 time = 880
* CHECK dout0_7 vdout0_7ck175 = 1.1 time = 880
* CHECK dout0_8 vdout0_8ck175 = 0 time = 880
* CHECK dout0_9 vdout0_9ck175 = 0 time = 880
* CHECK dout0_10 vdout0_10ck175 = 0 time = 880
* CHECK dout0_11 vdout0_11ck175 = 0 time = 880
* CHECK dout0_12 vdout0_12ck175 = 1.1 time = 880
* CHECK dout0_13 vdout0_13ck175 = 1.1 time = 880
* CHECK dout0_14 vdout0_14ck175 = 0 time = 880
* CHECK dout0_15 vdout0_15ck175 = 0 time = 880
* CHECK dout0_16 vdout0_16ck175 = 0 time = 880
* CHECK dout0_17 vdout0_17ck175 = 0 time = 880
* CHECK dout0_18 vdout0_18ck175 = 1.1 time = 880
* CHECK dout0_19 vdout0_19ck175 = 1.1 time = 880
* CHECK dout0_20 vdout0_20ck175 = 1.1 time = 880
* CHECK dout0_21 vdout0_21ck175 = 1.1 time = 880
* CHECK dout0_22 vdout0_22ck175 = 0 time = 880
* CHECK dout0_23 vdout0_23ck175 = 0 time = 880
* CHECK dout0_24 vdout0_24ck175 = 1.1 time = 880
* CHECK dout0_25 vdout0_25ck175 = 1.1 time = 880
* CHECK dout0_26 vdout0_26ck175 = 1.1 time = 880
* CHECK dout0_27 vdout0_27ck175 = 0 time = 880
* CHECK dout0_28 vdout0_28ck175 = 1.1 time = 880
* CHECK dout0_29 vdout0_29ck175 = 1.1 time = 880
* CHECK dout0_30 vdout0_30ck175 = 0 time = 880
* CHECK dout0_31 vdout0_31ck175 = 1.1 time = 880
* CHECK dout0_0 vdout0_0ck176 = 0 time = 885
* CHECK dout0_1 vdout0_1ck176 = 0 time = 885
* CHECK dout0_2 vdout0_2ck176 = 1.1 time = 885
* CHECK dout0_3 vdout0_3ck176 = 0 time = 885
* CHECK dout0_4 vdout0_4ck176 = 1.1 time = 885
* CHECK dout0_5 vdout0_5ck176 = 1.1 time = 885
* CHECK dout0_6 vdout0_6ck176 = 1.1 time = 885
* CHECK dout0_7 vdout0_7ck176 = 1.1 time = 885
* CHECK dout0_8 vdout0_8ck176 = 0 time = 885
* CHECK dout0_9 vdout0_9ck176 = 0 time = 885
* CHECK dout0_10 vdout0_10ck176 = 1.1 time = 885
* CHECK dout0_11 vdout0_11ck176 = 1.1 time = 885
* CHECK dout0_12 vdout0_12ck176 = 1.1 time = 885
* CHECK dout0_13 vdout0_13ck176 = 0 time = 885
* CHECK dout0_14 vdout0_14ck176 = 1.1 time = 885
* CHECK dout0_15 vdout0_15ck176 = 1.1 time = 885
* CHECK dout0_16 vdout0_16ck176 = 1.1 time = 885
* CHECK dout0_17 vdout0_17ck176 = 1.1 time = 885
* CHECK dout0_18 vdout0_18ck176 = 1.1 time = 885
* CHECK dout0_19 vdout0_19ck176 = 0 time = 885
* CHECK dout0_20 vdout0_20ck176 = 1.1 time = 885
* CHECK dout0_21 vdout0_21ck176 = 0 time = 885
* CHECK dout0_22 vdout0_22ck176 = 0 time = 885
* CHECK dout0_23 vdout0_23ck176 = 1.1 time = 885
* CHECK dout0_24 vdout0_24ck176 = 0 time = 885
* CHECK dout0_25 vdout0_25ck176 = 0 time = 885
* CHECK dout0_26 vdout0_26ck176 = 0 time = 885
* CHECK dout0_27 vdout0_27ck176 = 0 time = 885
* CHECK dout0_28 vdout0_28ck176 = 1.1 time = 885
* CHECK dout0_29 vdout0_29ck176 = 1.1 time = 885
* CHECK dout0_30 vdout0_30ck176 = 0 time = 885
* CHECK dout0_31 vdout0_31ck176 = 0 time = 885
* CHECK dout0_0 vdout0_0ck180 = 0 time = 905
* CHECK dout0_1 vdout0_1ck180 = 0 time = 905
* CHECK dout0_2 vdout0_2ck180 = 1.1 time = 905
* CHECK dout0_3 vdout0_3ck180 = 0 time = 905
* CHECK dout0_4 vdout0_4ck180 = 1.1 time = 905
* CHECK dout0_5 vdout0_5ck180 = 1.1 time = 905
* CHECK dout0_6 vdout0_6ck180 = 1.1 time = 905
* CHECK dout0_7 vdout0_7ck180 = 1.1 time = 905
* CHECK dout0_8 vdout0_8ck180 = 0 time = 905
* CHECK dout0_9 vdout0_9ck180 = 0 time = 905
* CHECK dout0_10 vdout0_10ck180 = 1.1 time = 905
* CHECK dout0_11 vdout0_11ck180 = 1.1 time = 905
* CHECK dout0_12 vdout0_12ck180 = 1.1 time = 905
* CHECK dout0_13 vdout0_13ck180 = 0 time = 905
* CHECK dout0_14 vdout0_14ck180 = 1.1 time = 905
* CHECK dout0_15 vdout0_15ck180 = 1.1 time = 905
* CHECK dout0_16 vdout0_16ck180 = 1.1 time = 905
* CHECK dout0_17 vdout0_17ck180 = 1.1 time = 905
* CHECK dout0_18 vdout0_18ck180 = 1.1 time = 905
* CHECK dout0_19 vdout0_19ck180 = 0 time = 905
* CHECK dout0_20 vdout0_20ck180 = 1.1 time = 905
* CHECK dout0_21 vdout0_21ck180 = 0 time = 905
* CHECK dout0_22 vdout0_22ck180 = 0 time = 905
* CHECK dout0_23 vdout0_23ck180 = 1.1 time = 905
* CHECK dout0_24 vdout0_24ck180 = 0 time = 905
* CHECK dout0_25 vdout0_25ck180 = 0 time = 905
* CHECK dout0_26 vdout0_26ck180 = 0 time = 905
* CHECK dout0_27 vdout0_27ck180 = 0 time = 905
* CHECK dout0_28 vdout0_28ck180 = 1.1 time = 905
* CHECK dout0_29 vdout0_29ck180 = 1.1 time = 905
* CHECK dout0_30 vdout0_30ck180 = 0 time = 905
* CHECK dout0_31 vdout0_31ck180 = 0 time = 905
* CHECK dout0_0 vdout0_0ck181 = 0 time = 910
* CHECK dout0_1 vdout0_1ck181 = 1.1 time = 910
* CHECK dout0_2 vdout0_2ck181 = 0 time = 910
* CHECK dout0_3 vdout0_3ck181 = 0 time = 910
* CHECK dout0_4 vdout0_4ck181 = 1.1 time = 910
* CHECK dout0_5 vdout0_5ck181 = 1.1 time = 910
* CHECK dout0_6 vdout0_6ck181 = 0 time = 910
* CHECK dout0_7 vdout0_7ck181 = 1.1 time = 910
* CHECK dout0_8 vdout0_8ck181 = 0 time = 910
* CHECK dout0_9 vdout0_9ck181 = 0 time = 910
* CHECK dout0_10 vdout0_10ck181 = 1.1 time = 910
* CHECK dout0_11 vdout0_11ck181 = 0 time = 910
* CHECK dout0_12 vdout0_12ck181 = 0 time = 910
* CHECK dout0_13 vdout0_13ck181 = 1.1 time = 910
* CHECK dout0_14 vdout0_14ck181 = 0 time = 910
* CHECK dout0_15 vdout0_15ck181 = 0 time = 910
* CHECK dout0_16 vdout0_16ck181 = 0 time = 910
* CHECK dout0_17 vdout0_17ck181 = 1.1 time = 910
* CHECK dout0_18 vdout0_18ck181 = 0 time = 910
* CHECK dout0_19 vdout0_19ck181 = 0 time = 910
* CHECK dout0_20 vdout0_20ck181 = 1.1 time = 910
* CHECK dout0_21 vdout0_21ck181 = 1.1 time = 910
* CHECK dout0_22 vdout0_22ck181 = 1.1 time = 910
* CHECK dout0_23 vdout0_23ck181 = 0 time = 910
* CHECK dout0_24 vdout0_24ck181 = 1.1 time = 910
* CHECK dout0_25 vdout0_25ck181 = 1.1 time = 910
* CHECK dout0_26 vdout0_26ck181 = 0 time = 910
* CHECK dout0_27 vdout0_27ck181 = 1.1 time = 910
* CHECK dout0_28 vdout0_28ck181 = 0 time = 910
* CHECK dout0_29 vdout0_29ck181 = 1.1 time = 910
* CHECK dout0_30 vdout0_30ck181 = 0 time = 910
* CHECK dout0_31 vdout0_31ck181 = 0 time = 910
* CHECK dout0_0 vdout0_0ck182 = 1.1 time = 915
* CHECK dout0_1 vdout0_1ck182 = 1.1 time = 915
* CHECK dout0_2 vdout0_2ck182 = 0 time = 915
* CHECK dout0_3 vdout0_3ck182 = 1.1 time = 915
* CHECK dout0_4 vdout0_4ck182 = 1.1 time = 915
* CHECK dout0_5 vdout0_5ck182 = 1.1 time = 915
* CHECK dout0_6 vdout0_6ck182 = 0 time = 915
* CHECK dout0_7 vdout0_7ck182 = 0 time = 915
* CHECK dout0_8 vdout0_8ck182 = 1.1 time = 915
* CHECK dout0_9 vdout0_9ck182 = 0 time = 915
* CHECK dout0_10 vdout0_10ck182 = 1.1 time = 915
* CHECK dout0_11 vdout0_11ck182 = 1.1 time = 915
* CHECK dout0_12 vdout0_12ck182 = 0 time = 915
* CHECK dout0_13 vdout0_13ck182 = 1.1 time = 915
* CHECK dout0_14 vdout0_14ck182 = 1.1 time = 915
* CHECK dout0_15 vdout0_15ck182 = 1.1 time = 915
* CHECK dout0_16 vdout0_16ck182 = 0 time = 915
* CHECK dout0_17 vdout0_17ck182 = 1.1 time = 915
* CHECK dout0_18 vdout0_18ck182 = 1.1 time = 915
* CHECK dout0_19 vdout0_19ck182 = 0 time = 915
* CHECK dout0_20 vdout0_20ck182 = 0 time = 915
* CHECK dout0_21 vdout0_21ck182 = 1.1 time = 915
* CHECK dout0_22 vdout0_22ck182 = 1.1 time = 915
* CHECK dout0_23 vdout0_23ck182 = 0 time = 915
* CHECK dout0_24 vdout0_24ck182 = 1.1 time = 915
* CHECK dout0_25 vdout0_25ck182 = 0 time = 915
* CHECK dout0_26 vdout0_26ck182 = 0 time = 915
* CHECK dout0_27 vdout0_27ck182 = 1.1 time = 915
* CHECK dout0_28 vdout0_28ck182 = 1.1 time = 915
* CHECK dout0_29 vdout0_29ck182 = 0 time = 915
* CHECK dout0_30 vdout0_30ck182 = 1.1 time = 915
* CHECK dout0_31 vdout0_31ck182 = 1.1 time = 915
* CHECK dout0_0 vdout0_0ck183 = 1.1 time = 920
* CHECK dout0_1 vdout0_1ck183 = 1.1 time = 920
* CHECK dout0_2 vdout0_2ck183 = 1.1 time = 920
* CHECK dout0_3 vdout0_3ck183 = 1.1 time = 920
* CHECK dout0_4 vdout0_4ck183 = 1.1 time = 920
* CHECK dout0_5 vdout0_5ck183 = 0 time = 920
* CHECK dout0_6 vdout0_6ck183 = 1.1 time = 920
* CHECK dout0_7 vdout0_7ck183 = 1.1 time = 920
* CHECK dout0_8 vdout0_8ck183 = 1.1 time = 920
* CHECK dout0_9 vdout0_9ck183 = 1.1 time = 920
* CHECK dout0_10 vdout0_10ck183 = 0 time = 920
* CHECK dout0_11 vdout0_11ck183 = 1.1 time = 920
* CHECK dout0_12 vdout0_12ck183 = 0 time = 920
* CHECK dout0_13 vdout0_13ck183 = 0 time = 920
* CHECK dout0_14 vdout0_14ck183 = 0 time = 920
* CHECK dout0_15 vdout0_15ck183 = 1.1 time = 920
* CHECK dout0_16 vdout0_16ck183 = 0 time = 920
* CHECK dout0_17 vdout0_17ck183 = 1.1 time = 920
* CHECK dout0_18 vdout0_18ck183 = 1.1 time = 920
* CHECK dout0_19 vdout0_19ck183 = 0 time = 920
* CHECK dout0_20 vdout0_20ck183 = 1.1 time = 920
* CHECK dout0_21 vdout0_21ck183 = 1.1 time = 920
* CHECK dout0_22 vdout0_22ck183 = 1.1 time = 920
* CHECK dout0_23 vdout0_23ck183 = 1.1 time = 920
* CHECK dout0_24 vdout0_24ck183 = 0 time = 920
* CHECK dout0_25 vdout0_25ck183 = 1.1 time = 920
* CHECK dout0_26 vdout0_26ck183 = 0 time = 920
* CHECK dout0_27 vdout0_27ck183 = 0 time = 920
* CHECK dout0_28 vdout0_28ck183 = 1.1 time = 920
* CHECK dout0_29 vdout0_29ck183 = 0 time = 920
* CHECK dout0_30 vdout0_30ck183 = 1.1 time = 920
* CHECK dout0_31 vdout0_31ck183 = 0 time = 920
* CHECK dout0_0 vdout0_0ck185 = 0 time = 930
* CHECK dout0_1 vdout0_1ck185 = 1.1 time = 930
* CHECK dout0_2 vdout0_2ck185 = 0 time = 930
* CHECK dout0_3 vdout0_3ck185 = 0 time = 930
* CHECK dout0_4 vdout0_4ck185 = 1.1 time = 930
* CHECK dout0_5 vdout0_5ck185 = 1.1 time = 930
* CHECK dout0_6 vdout0_6ck185 = 0 time = 930
* CHECK dout0_7 vdout0_7ck185 = 1.1 time = 930
* CHECK dout0_8 vdout0_8ck185 = 0 time = 930
* CHECK dout0_9 vdout0_9ck185 = 0 time = 930
* CHECK dout0_10 vdout0_10ck185 = 1.1 time = 930
* CHECK dout0_11 vdout0_11ck185 = 0 time = 930
* CHECK dout0_12 vdout0_12ck185 = 0 time = 930
* CHECK dout0_13 vdout0_13ck185 = 1.1 time = 930
* CHECK dout0_14 vdout0_14ck185 = 0 time = 930
* CHECK dout0_15 vdout0_15ck185 = 0 time = 930
* CHECK dout0_16 vdout0_16ck185 = 0 time = 930
* CHECK dout0_17 vdout0_17ck185 = 1.1 time = 930
* CHECK dout0_18 vdout0_18ck185 = 0 time = 930
* CHECK dout0_19 vdout0_19ck185 = 0 time = 930
* CHECK dout0_20 vdout0_20ck185 = 1.1 time = 930
* CHECK dout0_21 vdout0_21ck185 = 1.1 time = 930
* CHECK dout0_22 vdout0_22ck185 = 1.1 time = 930
* CHECK dout0_23 vdout0_23ck185 = 0 time = 930
* CHECK dout0_24 vdout0_24ck185 = 1.1 time = 930
* CHECK dout0_25 vdout0_25ck185 = 1.1 time = 930
* CHECK dout0_26 vdout0_26ck185 = 0 time = 930
* CHECK dout0_27 vdout0_27ck185 = 1.1 time = 930
* CHECK dout0_28 vdout0_28ck185 = 0 time = 930
* CHECK dout0_29 vdout0_29ck185 = 1.1 time = 930
* CHECK dout0_30 vdout0_30ck185 = 0 time = 930
* CHECK dout0_31 vdout0_31ck185 = 0 time = 930
* CHECK dout0_0 vdout0_0ck186 = 1.1 time = 935
* CHECK dout0_1 vdout0_1ck186 = 1.1 time = 935
* CHECK dout0_2 vdout0_2ck186 = 1.1 time = 935
* CHECK dout0_3 vdout0_3ck186 = 1.1 time = 935
* CHECK dout0_4 vdout0_4ck186 = 1.1 time = 935
* CHECK dout0_5 vdout0_5ck186 = 0 time = 935
* CHECK dout0_6 vdout0_6ck186 = 1.1 time = 935
* CHECK dout0_7 vdout0_7ck186 = 1.1 time = 935
* CHECK dout0_8 vdout0_8ck186 = 1.1 time = 935
* CHECK dout0_9 vdout0_9ck186 = 1.1 time = 935
* CHECK dout0_10 vdout0_10ck186 = 0 time = 935
* CHECK dout0_11 vdout0_11ck186 = 1.1 time = 935
* CHECK dout0_12 vdout0_12ck186 = 0 time = 935
* CHECK dout0_13 vdout0_13ck186 = 0 time = 935
* CHECK dout0_14 vdout0_14ck186 = 0 time = 935
* CHECK dout0_15 vdout0_15ck186 = 1.1 time = 935
* CHECK dout0_16 vdout0_16ck186 = 0 time = 935
* CHECK dout0_17 vdout0_17ck186 = 1.1 time = 935
* CHECK dout0_18 vdout0_18ck186 = 1.1 time = 935
* CHECK dout0_19 vdout0_19ck186 = 0 time = 935
* CHECK dout0_20 vdout0_20ck186 = 1.1 time = 935
* CHECK dout0_21 vdout0_21ck186 = 1.1 time = 935
* CHECK dout0_22 vdout0_22ck186 = 1.1 time = 935
* CHECK dout0_23 vdout0_23ck186 = 1.1 time = 935
* CHECK dout0_24 vdout0_24ck186 = 0 time = 935
* CHECK dout0_25 vdout0_25ck186 = 1.1 time = 935
* CHECK dout0_26 vdout0_26ck186 = 0 time = 935
* CHECK dout0_27 vdout0_27ck186 = 0 time = 935
* CHECK dout0_28 vdout0_28ck186 = 1.1 time = 935
* CHECK dout0_29 vdout0_29ck186 = 0 time = 935
* CHECK dout0_30 vdout0_30ck186 = 1.1 time = 935
* CHECK dout0_31 vdout0_31ck186 = 0 time = 935
* CHECK dout0_0 vdout0_0ck187 = 1.1 time = 940
* CHECK dout0_1 vdout0_1ck187 = 1.1 time = 940
* CHECK dout0_2 vdout0_2ck187 = 1.1 time = 940
* CHECK dout0_3 vdout0_3ck187 = 1.1 time = 940
* CHECK dout0_4 vdout0_4ck187 = 1.1 time = 940
* CHECK dout0_5 vdout0_5ck187 = 0 time = 940
* CHECK dout0_6 vdout0_6ck187 = 1.1 time = 940
* CHECK dout0_7 vdout0_7ck187 = 1.1 time = 940
* CHECK dout0_8 vdout0_8ck187 = 1.1 time = 940
* CHECK dout0_9 vdout0_9ck187 = 1.1 time = 940
* CHECK dout0_10 vdout0_10ck187 = 0 time = 940
* CHECK dout0_11 vdout0_11ck187 = 1.1 time = 940
* CHECK dout0_12 vdout0_12ck187 = 0 time = 940
* CHECK dout0_13 vdout0_13ck187 = 0 time = 940
* CHECK dout0_14 vdout0_14ck187 = 0 time = 940
* CHECK dout0_15 vdout0_15ck187 = 1.1 time = 940
* CHECK dout0_16 vdout0_16ck187 = 0 time = 940
* CHECK dout0_17 vdout0_17ck187 = 1.1 time = 940
* CHECK dout0_18 vdout0_18ck187 = 1.1 time = 940
* CHECK dout0_19 vdout0_19ck187 = 0 time = 940
* CHECK dout0_20 vdout0_20ck187 = 1.1 time = 940
* CHECK dout0_21 vdout0_21ck187 = 1.1 time = 940
* CHECK dout0_22 vdout0_22ck187 = 1.1 time = 940
* CHECK dout0_23 vdout0_23ck187 = 1.1 time = 940
* CHECK dout0_24 vdout0_24ck187 = 0 time = 940
* CHECK dout0_25 vdout0_25ck187 = 1.1 time = 940
* CHECK dout0_26 vdout0_26ck187 = 0 time = 940
* CHECK dout0_27 vdout0_27ck187 = 0 time = 940
* CHECK dout0_28 vdout0_28ck187 = 1.1 time = 940
* CHECK dout0_29 vdout0_29ck187 = 0 time = 940
* CHECK dout0_30 vdout0_30ck187 = 1.1 time = 940
* CHECK dout0_31 vdout0_31ck187 = 0 time = 940
* CHECK dout0_0 vdout0_0ck189 = 0 time = 950
* CHECK dout0_1 vdout0_1ck189 = 0 time = 950
* CHECK dout0_2 vdout0_2ck189 = 1.1 time = 950
* CHECK dout0_3 vdout0_3ck189 = 1.1 time = 950
* CHECK dout0_4 vdout0_4ck189 = 1.1 time = 950
* CHECK dout0_5 vdout0_5ck189 = 0 time = 950
* CHECK dout0_6 vdout0_6ck189 = 1.1 time = 950
* CHECK dout0_7 vdout0_7ck189 = 0 time = 950
* CHECK dout0_8 vdout0_8ck189 = 1.1 time = 950
* CHECK dout0_9 vdout0_9ck189 = 0 time = 950
* CHECK dout0_10 vdout0_10ck189 = 1.1 time = 950
* CHECK dout0_11 vdout0_11ck189 = 1.1 time = 950
* CHECK dout0_12 vdout0_12ck189 = 1.1 time = 950
* CHECK dout0_13 vdout0_13ck189 = 0 time = 950
* CHECK dout0_14 vdout0_14ck189 = 0 time = 950
* CHECK dout0_15 vdout0_15ck189 = 1.1 time = 950
* CHECK dout0_16 vdout0_16ck189 = 1.1 time = 950
* CHECK dout0_17 vdout0_17ck189 = 1.1 time = 950
* CHECK dout0_18 vdout0_18ck189 = 0 time = 950
* CHECK dout0_19 vdout0_19ck189 = 1.1 time = 950
* CHECK dout0_20 vdout0_20ck189 = 1.1 time = 950
* CHECK dout0_21 vdout0_21ck189 = 0 time = 950
* CHECK dout0_22 vdout0_22ck189 = 0 time = 950
* CHECK dout0_23 vdout0_23ck189 = 1.1 time = 950
* CHECK dout0_24 vdout0_24ck189 = 0 time = 950
* CHECK dout0_25 vdout0_25ck189 = 1.1 time = 950
* CHECK dout0_26 vdout0_26ck189 = 0 time = 950
* CHECK dout0_27 vdout0_27ck189 = 1.1 time = 950
* CHECK dout0_28 vdout0_28ck189 = 0 time = 950
* CHECK dout0_29 vdout0_29ck189 = 1.1 time = 950
* CHECK dout0_30 vdout0_30ck189 = 1.1 time = 950
* CHECK dout0_31 vdout0_31ck189 = 0 time = 950
* CHECK dout0_0 vdout0_0ck190 = 0 time = 955
* CHECK dout0_1 vdout0_1ck190 = 0 time = 955
* CHECK dout0_2 vdout0_2ck190 = 1.1 time = 955
* CHECK dout0_3 vdout0_3ck190 = 0 time = 955
* CHECK dout0_4 vdout0_4ck190 = 0 time = 955
* CHECK dout0_5 vdout0_5ck190 = 0 time = 955
* CHECK dout0_6 vdout0_6ck190 = 0 time = 955
* CHECK dout0_7 vdout0_7ck190 = 0 time = 955
* CHECK dout0_8 vdout0_8ck190 = 0 time = 955
* CHECK dout0_9 vdout0_9ck190 = 1.1 time = 955
* CHECK dout0_10 vdout0_10ck190 = 1.1 time = 955
* CHECK dout0_11 vdout0_11ck190 = 0 time = 955
* CHECK dout0_12 vdout0_12ck190 = 1.1 time = 955
* CHECK dout0_13 vdout0_13ck190 = 1.1 time = 955
* CHECK dout0_14 vdout0_14ck190 = 1.1 time = 955
* CHECK dout0_15 vdout0_15ck190 = 0 time = 955
* CHECK dout0_16 vdout0_16ck190 = 1.1 time = 955
* CHECK dout0_17 vdout0_17ck190 = 1.1 time = 955
* CHECK dout0_18 vdout0_18ck190 = 0 time = 955
* CHECK dout0_19 vdout0_19ck190 = 0 time = 955
* CHECK dout0_20 vdout0_20ck190 = 1.1 time = 955
* CHECK dout0_21 vdout0_21ck190 = 0 time = 955
* CHECK dout0_22 vdout0_22ck190 = 1.1 time = 955
* CHECK dout0_23 vdout0_23ck190 = 0 time = 955
* CHECK dout0_24 vdout0_24ck190 = 1.1 time = 955
* CHECK dout0_25 vdout0_25ck190 = 1.1 time = 955
* CHECK dout0_26 vdout0_26ck190 = 1.1 time = 955
* CHECK dout0_27 vdout0_27ck190 = 1.1 time = 955
* CHECK dout0_28 vdout0_28ck190 = 0 time = 955
* CHECK dout0_29 vdout0_29ck190 = 1.1 time = 955
* CHECK dout0_30 vdout0_30ck190 = 0 time = 955
* CHECK dout0_31 vdout0_31ck190 = 1.1 time = 955
* CHECK dout0_0 vdout0_0ck193 = 1.1 time = 970
* CHECK dout0_1 vdout0_1ck193 = 1.1 time = 970
* CHECK dout0_2 vdout0_2ck193 = 1.1 time = 970
* CHECK dout0_3 vdout0_3ck193 = 1.1 time = 970
* CHECK dout0_4 vdout0_4ck193 = 1.1 time = 970
* CHECK dout0_5 vdout0_5ck193 = 0 time = 970
* CHECK dout0_6 vdout0_6ck193 = 1.1 time = 970
* CHECK dout0_7 vdout0_7ck193 = 1.1 time = 970
* CHECK dout0_8 vdout0_8ck193 = 1.1 time = 970
* CHECK dout0_9 vdout0_9ck193 = 1.1 time = 970
* CHECK dout0_10 vdout0_10ck193 = 0 time = 970
* CHECK dout0_11 vdout0_11ck193 = 1.1 time = 970
* CHECK dout0_12 vdout0_12ck193 = 0 time = 970
* CHECK dout0_13 vdout0_13ck193 = 0 time = 970
* CHECK dout0_14 vdout0_14ck193 = 0 time = 970
* CHECK dout0_15 vdout0_15ck193 = 1.1 time = 970
* CHECK dout0_16 vdout0_16ck193 = 0 time = 970
* CHECK dout0_17 vdout0_17ck193 = 1.1 time = 970
* CHECK dout0_18 vdout0_18ck193 = 1.1 time = 970
* CHECK dout0_19 vdout0_19ck193 = 0 time = 970
* CHECK dout0_20 vdout0_20ck193 = 1.1 time = 970
* CHECK dout0_21 vdout0_21ck193 = 1.1 time = 970
* CHECK dout0_22 vdout0_22ck193 = 1.1 time = 970
* CHECK dout0_23 vdout0_23ck193 = 1.1 time = 970
* CHECK dout0_24 vdout0_24ck193 = 0 time = 970
* CHECK dout0_25 vdout0_25ck193 = 1.1 time = 970
* CHECK dout0_26 vdout0_26ck193 = 0 time = 970
* CHECK dout0_27 vdout0_27ck193 = 0 time = 970
* CHECK dout0_28 vdout0_28ck193 = 1.1 time = 970
* CHECK dout0_29 vdout0_29ck193 = 0 time = 970
* CHECK dout0_30 vdout0_30ck193 = 1.1 time = 970
* CHECK dout0_31 vdout0_31ck193 = 0 time = 970
* CHECK dout0_0 vdout0_0ck194 = 1.1 time = 975
* CHECK dout0_1 vdout0_1ck194 = 1.1 time = 975
* CHECK dout0_2 vdout0_2ck194 = 1.1 time = 975
* CHECK dout0_3 vdout0_3ck194 = 1.1 time = 975
* CHECK dout0_4 vdout0_4ck194 = 1.1 time = 975
* CHECK dout0_5 vdout0_5ck194 = 1.1 time = 975
* CHECK dout0_6 vdout0_6ck194 = 1.1 time = 975
* CHECK dout0_7 vdout0_7ck194 = 0 time = 975
* CHECK dout0_8 vdout0_8ck194 = 0 time = 975
* CHECK dout0_9 vdout0_9ck194 = 1.1 time = 975
* CHECK dout0_10 vdout0_10ck194 = 1.1 time = 975
* CHECK dout0_11 vdout0_11ck194 = 0 time = 975
* CHECK dout0_12 vdout0_12ck194 = 1.1 time = 975
* CHECK dout0_13 vdout0_13ck194 = 0 time = 975
* CHECK dout0_14 vdout0_14ck194 = 0 time = 975
* CHECK dout0_15 vdout0_15ck194 = 0 time = 975
* CHECK dout0_16 vdout0_16ck194 = 1.1 time = 975
* CHECK dout0_17 vdout0_17ck194 = 1.1 time = 975
* CHECK dout0_18 vdout0_18ck194 = 0 time = 975
* CHECK dout0_19 vdout0_19ck194 = 1.1 time = 975
* CHECK dout0_20 vdout0_20ck194 = 0 time = 975
* CHECK dout0_21 vdout0_21ck194 = 1.1 time = 975
* CHECK dout0_22 vdout0_22ck194 = 0 time = 975
* CHECK dout0_23 vdout0_23ck194 = 1.1 time = 975
* CHECK dout0_24 vdout0_24ck194 = 0 time = 975
* CHECK dout0_25 vdout0_25ck194 = 1.1 time = 975
* CHECK dout0_26 vdout0_26ck194 = 1.1 time = 975
* CHECK dout0_27 vdout0_27ck194 = 0 time = 975
* CHECK dout0_28 vdout0_28ck194 = 0 time = 975
* CHECK dout0_29 vdout0_29ck194 = 0 time = 975
* CHECK dout0_30 vdout0_30ck194 = 1.1 time = 975
* CHECK dout0_31 vdout0_31ck194 = 0 time = 975
* CHECK dout0_0 vdout0_0ck196 = 0 time = 985
* CHECK dout0_1 vdout0_1ck196 = 0 time = 985
* CHECK dout0_2 vdout0_2ck196 = 0 time = 985
* CHECK dout0_3 vdout0_3ck196 = 1.1 time = 985
* CHECK dout0_4 vdout0_4ck196 = 0 time = 985
* CHECK dout0_5 vdout0_5ck196 = 0 time = 985
* CHECK dout0_6 vdout0_6ck196 = 1.1 time = 985
* CHECK dout0_7 vdout0_7ck196 = 1.1 time = 985
* CHECK dout0_8 vdout0_8ck196 = 0 time = 985
* CHECK dout0_9 vdout0_9ck196 = 0 time = 985
* CHECK dout0_10 vdout0_10ck196 = 0 time = 985
* CHECK dout0_11 vdout0_11ck196 = 0 time = 985
* CHECK dout0_12 vdout0_12ck196 = 1.1 time = 985
* CHECK dout0_13 vdout0_13ck196 = 1.1 time = 985
* CHECK dout0_14 vdout0_14ck196 = 0 time = 985
* CHECK dout0_15 vdout0_15ck196 = 0 time = 985
* CHECK dout0_16 vdout0_16ck196 = 0 time = 985
* CHECK dout0_17 vdout0_17ck196 = 0 time = 985
* CHECK dout0_18 vdout0_18ck196 = 1.1 time = 985
* CHECK dout0_19 vdout0_19ck196 = 1.1 time = 985
* CHECK dout0_20 vdout0_20ck196 = 1.1 time = 985
* CHECK dout0_21 vdout0_21ck196 = 1.1 time = 985
* CHECK dout0_22 vdout0_22ck196 = 0 time = 985
* CHECK dout0_23 vdout0_23ck196 = 0 time = 985
* CHECK dout0_24 vdout0_24ck196 = 1.1 time = 985
* CHECK dout0_25 vdout0_25ck196 = 1.1 time = 985
* CHECK dout0_26 vdout0_26ck196 = 1.1 time = 985
* CHECK dout0_27 vdout0_27ck196 = 0 time = 985
* CHECK dout0_28 vdout0_28ck196 = 1.1 time = 985
* CHECK dout0_29 vdout0_29ck196 = 1.1 time = 985
* CHECK dout0_30 vdout0_30ck196 = 0 time = 985
* CHECK dout0_31 vdout0_31ck196 = 1.1 time = 985
* CHECK dout0_0 vdout0_0ck199 = 1.1 time = 1000
* CHECK dout0_1 vdout0_1ck199 = 1.1 time = 1000
* CHECK dout0_2 vdout0_2ck199 = 1.1 time = 1000
* CHECK dout0_3 vdout0_3ck199 = 1.1 time = 1000
* CHECK dout0_4 vdout0_4ck199 = 1.1 time = 1000
* CHECK dout0_5 vdout0_5ck199 = 0 time = 1000
* CHECK dout0_6 vdout0_6ck199 = 1.1 time = 1000
* CHECK dout0_7 vdout0_7ck199 = 1.1 time = 1000
* CHECK dout0_8 vdout0_8ck199 = 1.1 time = 1000
* CHECK dout0_9 vdout0_9ck199 = 1.1 time = 1000
* CHECK dout0_10 vdout0_10ck199 = 0 time = 1000
* CHECK dout0_11 vdout0_11ck199 = 1.1 time = 1000
* CHECK dout0_12 vdout0_12ck199 = 0 time = 1000
* CHECK dout0_13 vdout0_13ck199 = 0 time = 1000
* CHECK dout0_14 vdout0_14ck199 = 0 time = 1000
* CHECK dout0_15 vdout0_15ck199 = 1.1 time = 1000
* CHECK dout0_16 vdout0_16ck199 = 0 time = 1000
* CHECK dout0_17 vdout0_17ck199 = 1.1 time = 1000
* CHECK dout0_18 vdout0_18ck199 = 1.1 time = 1000
* CHECK dout0_19 vdout0_19ck199 = 0 time = 1000
* CHECK dout0_20 vdout0_20ck199 = 1.1 time = 1000
* CHECK dout0_21 vdout0_21ck199 = 1.1 time = 1000
* CHECK dout0_22 vdout0_22ck199 = 1.1 time = 1000
* CHECK dout0_23 vdout0_23ck199 = 1.1 time = 1000
* CHECK dout0_24 vdout0_24ck199 = 0 time = 1000
* CHECK dout0_25 vdout0_25ck199 = 1.1 time = 1000
* CHECK dout0_26 vdout0_26ck199 = 0 time = 1000
* CHECK dout0_27 vdout0_27ck199 = 0 time = 1000
* CHECK dout0_28 vdout0_28ck199 = 1.1 time = 1000
* CHECK dout0_29 vdout0_29ck199 = 0 time = 1000
* CHECK dout0_30 vdout0_30ck199 = 1.1 time = 1000
* CHECK dout0_31 vdout0_31ck199 = 0 time = 1000
* CHECK dout0_0 vdout0_0ck200 = 0 time = 1005
* CHECK dout0_1 vdout0_1ck200 = 0 time = 1005
* CHECK dout0_2 vdout0_2ck200 = 1.1 time = 1005
* CHECK dout0_3 vdout0_3ck200 = 1.1 time = 1005
* CHECK dout0_4 vdout0_4ck200 = 1.1 time = 1005
* CHECK dout0_5 vdout0_5ck200 = 0 time = 1005
* CHECK dout0_6 vdout0_6ck200 = 1.1 time = 1005
* CHECK dout0_7 vdout0_7ck200 = 0 time = 1005
* CHECK dout0_8 vdout0_8ck200 = 1.1 time = 1005
* CHECK dout0_9 vdout0_9ck200 = 0 time = 1005
* CHECK dout0_10 vdout0_10ck200 = 1.1 time = 1005
* CHECK dout0_11 vdout0_11ck200 = 1.1 time = 1005
* CHECK dout0_12 vdout0_12ck200 = 1.1 time = 1005
* CHECK dout0_13 vdout0_13ck200 = 0 time = 1005
* CHECK dout0_14 vdout0_14ck200 = 0 time = 1005
* CHECK dout0_15 vdout0_15ck200 = 1.1 time = 1005
* CHECK dout0_16 vdout0_16ck200 = 1.1 time = 1005
* CHECK dout0_17 vdout0_17ck200 = 1.1 time = 1005
* CHECK dout0_18 vdout0_18ck200 = 0 time = 1005
* CHECK dout0_19 vdout0_19ck200 = 1.1 time = 1005
* CHECK dout0_20 vdout0_20ck200 = 1.1 time = 1005
* CHECK dout0_21 vdout0_21ck200 = 0 time = 1005
* CHECK dout0_22 vdout0_22ck200 = 0 time = 1005
* CHECK dout0_23 vdout0_23ck200 = 1.1 time = 1005
* CHECK dout0_24 vdout0_24ck200 = 0 time = 1005
* CHECK dout0_25 vdout0_25ck200 = 1.1 time = 1005
* CHECK dout0_26 vdout0_26ck200 = 0 time = 1005
* CHECK dout0_27 vdout0_27ck200 = 1.1 time = 1005
* CHECK dout0_28 vdout0_28ck200 = 0 time = 1005
* CHECK dout0_29 vdout0_29ck200 = 1.1 time = 1005
* CHECK dout0_30 vdout0_30ck200 = 1.1 time = 1005
* CHECK dout0_31 vdout0_31ck200 = 0 time = 1005
* CHECK dout0_0 vdout0_0ck201 = 0 time = 1010
* CHECK dout0_1 vdout0_1ck201 = 1.1 time = 1010
* CHECK dout0_2 vdout0_2ck201 = 0 time = 1010
* CHECK dout0_3 vdout0_3ck201 = 0 time = 1010
* CHECK dout0_4 vdout0_4ck201 = 1.1 time = 1010
* CHECK dout0_5 vdout0_5ck201 = 1.1 time = 1010
* CHECK dout0_6 vdout0_6ck201 = 0 time = 1010
* CHECK dout0_7 vdout0_7ck201 = 1.1 time = 1010
* CHECK dout0_8 vdout0_8ck201 = 0 time = 1010
* CHECK dout0_9 vdout0_9ck201 = 0 time = 1010
* CHECK dout0_10 vdout0_10ck201 = 1.1 time = 1010
* CHECK dout0_11 vdout0_11ck201 = 0 time = 1010
* CHECK dout0_12 vdout0_12ck201 = 0 time = 1010
* CHECK dout0_13 vdout0_13ck201 = 1.1 time = 1010
* CHECK dout0_14 vdout0_14ck201 = 0 time = 1010
* CHECK dout0_15 vdout0_15ck201 = 0 time = 1010
* CHECK dout0_16 vdout0_16ck201 = 0 time = 1010
* CHECK dout0_17 vdout0_17ck201 = 1.1 time = 1010
* CHECK dout0_18 vdout0_18ck201 = 0 time = 1010
* CHECK dout0_19 vdout0_19ck201 = 0 time = 1010
* CHECK dout0_20 vdout0_20ck201 = 1.1 time = 1010
* CHECK dout0_21 vdout0_21ck201 = 1.1 time = 1010
* CHECK dout0_22 vdout0_22ck201 = 1.1 time = 1010
* CHECK dout0_23 vdout0_23ck201 = 0 time = 1010
* CHECK dout0_24 vdout0_24ck201 = 1.1 time = 1010
* CHECK dout0_25 vdout0_25ck201 = 1.1 time = 1010
* CHECK dout0_26 vdout0_26ck201 = 0 time = 1010
* CHECK dout0_27 vdout0_27ck201 = 1.1 time = 1010
* CHECK dout0_28 vdout0_28ck201 = 0 time = 1010
* CHECK dout0_29 vdout0_29ck201 = 1.1 time = 1010
* CHECK dout0_30 vdout0_30ck201 = 0 time = 1010
* CHECK dout0_31 vdout0_31ck201 = 0 time = 1010
* CHECK dout0_0 vdout0_0ck202 = 1.1 time = 1015
* CHECK dout0_1 vdout0_1ck202 = 1.1 time = 1015
* CHECK dout0_2 vdout0_2ck202 = 0 time = 1015
* CHECK dout0_3 vdout0_3ck202 = 0 time = 1015
* CHECK dout0_4 vdout0_4ck202 = 0 time = 1015
* CHECK dout0_5 vdout0_5ck202 = 0 time = 1015
* CHECK dout0_6 vdout0_6ck202 = 1.1 time = 1015
* CHECK dout0_7 vdout0_7ck202 = 1.1 time = 1015
* CHECK dout0_8 vdout0_8ck202 = 0 time = 1015
* CHECK dout0_9 vdout0_9ck202 = 0 time = 1015
* CHECK dout0_10 vdout0_10ck202 = 0 time = 1015
* CHECK dout0_11 vdout0_11ck202 = 0 time = 1015
* CHECK dout0_12 vdout0_12ck202 = 0 time = 1015
* CHECK dout0_13 vdout0_13ck202 = 1.1 time = 1015
* CHECK dout0_14 vdout0_14ck202 = 0 time = 1015
* CHECK dout0_15 vdout0_15ck202 = 1.1 time = 1015
* CHECK dout0_16 vdout0_16ck202 = 0 time = 1015
* CHECK dout0_17 vdout0_17ck202 = 1.1 time = 1015
* CHECK dout0_18 vdout0_18ck202 = 1.1 time = 1015
* CHECK dout0_19 vdout0_19ck202 = 1.1 time = 1015
* CHECK dout0_20 vdout0_20ck202 = 1.1 time = 1015
* CHECK dout0_21 vdout0_21ck202 = 0 time = 1015
* CHECK dout0_22 vdout0_22ck202 = 0 time = 1015
* CHECK dout0_23 vdout0_23ck202 = 0 time = 1015
* CHECK dout0_24 vdout0_24ck202 = 0 time = 1015
* CHECK dout0_25 vdout0_25ck202 = 0 time = 1015
* CHECK dout0_26 vdout0_26ck202 = 1.1 time = 1015
* CHECK dout0_27 vdout0_27ck202 = 1.1 time = 1015
* CHECK dout0_28 vdout0_28ck202 = 0 time = 1015
* CHECK dout0_29 vdout0_29ck202 = 1.1 time = 1015
* CHECK dout0_30 vdout0_30ck202 = 1.1 time = 1015
* CHECK dout0_31 vdout0_31ck202 = 1.1 time = 1015
.include /home/ivann/OpenRAM/SRAM_32x128_1rw/functional_meas.sp
* probe is used for hspice/xa, while plot is used in ngspice
*.probe V(*)
*.plot V(*)
.end
